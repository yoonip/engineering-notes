Fixed-resistor 64-50-10 MLP, fixed MNIST test index 15
* Generated by export_circuit.py. This deck has not been run by the exporter.
* 64 device conductance states, positive resistors, signed differential columns.
* Ideal finite-gain VCVS TIA; ideal behavioral bias, scaling, ReLU and output.
* No transistor model, memristor dynamics, programming pulses or extracted parasitics.
* hidden voltage = 0.01*activation; output voltage = 0.01*dimensionless logit.
.options reltol=1e-6 abstol=1e-12 vntol=1e-9
V_PIXEL_0 pixel_0 0 PWL(0 0 1u 0 1.1u 0 9u 0 9.1u 0 10u 0)
V_PIXEL_1 pixel_1 0 PWL(0 0 1u 0 1.1u 0 9u 0 9.1u 0 10u 0)
V_PIXEL_2 pixel_2 0 PWL(0 0 1u 0 1.1u 0 9u 0 9.1u 0 10u 0)
V_PIXEL_3 pixel_3 0 PWL(0 0 1u 0 1.1u 0 9u 0 9.1u 0 10u 0)
V_PIXEL_4 pixel_4 0 PWL(0 0 1u 0 1.1u 0 9u 0 9.1u 0 10u 0)
V_PIXEL_5 pixel_5 0 PWL(0 0 1u 0 1.1u 0 9u 0 9.1u 0 10u 0)
V_PIXEL_6 pixel_6 0 PWL(0 0 1u 0 1.1u 0 9u 0 9.1u 0 10u 0)
V_PIXEL_7 pixel_7 0 PWL(0 0 1u 0 1.1u 0 9u 0 9.1u 0 10u 0)
V_PIXEL_8 pixel_8 0 PWL(0 0 1u 0 1.1u 0 9u 0 9.1u 0 10u 0)
V_PIXEL_9 pixel_9 0 PWL(0 0 1u 0 1.1u 0 9u 0 9.1u 0 10u 0)
V_PIXEL_10 pixel_10 0 PWL(0 0 1u 0 1.1u 0.039215686917304995 9u 0.039215686917304995 9.1u 0 10u 0)
V_PIXEL_11 pixel_11 0 PWL(0 0 1u 0 1.1u 0.058431375026702884 9u 0.058431375026702884 9.1u 0 10u 0)
V_PIXEL_12 pixel_12 0 PWL(0 0 1u 0 1.1u 0.058431375026702884 9u 0.058431375026702884 9.1u 0 10u 0)
V_PIXEL_13 pixel_13 0 PWL(0 0 1u 0 1.1u 0.01764705926179886 9u 0.01764705926179886 9.1u 0 10u 0)
V_PIXEL_14 pixel_14 0 PWL(0 0 1u 0 1.1u 0 9u 0 9.1u 0 10u 0)
V_PIXEL_15 pixel_15 0 PWL(0 0 1u 0 1.1u 0 9u 0 9.1u 0 10u 0)
V_PIXEL_16 pixel_16 0 PWL(0 0 1u 0 1.1u 0 9u 0 9.1u 0 10u 0)
V_PIXEL_17 pixel_17 0 PWL(0 0 1u 0 1.1u 0 9u 0 9.1u 0 10u 0)
V_PIXEL_18 pixel_18 0 PWL(0 0 1u 0 1.1u 0.045490196347236639 9u 0.045490196347236639 9.1u 0 10u 0)
V_PIXEL_19 pixel_19 0 PWL(0 0 1u 0 1.1u 0.0090196080505847934 9u 0.0090196080505847934 9.1u 0 10u 0)
V_PIXEL_20 pixel_20 0 PWL(0 0 1u 0 1.1u 0.0015686275437474251 9u 0.0015686275437474251 9.1u 0 10u 0)
V_PIXEL_21 pixel_21 0 PWL(0 0 1u 0 1.1u 0 9u 0 9.1u 0 10u 0)
V_PIXEL_22 pixel_22 0 PWL(0 0 1u 0 1.1u 0 9u 0 9.1u 0 10u 0)
V_PIXEL_23 pixel_23 0 PWL(0 0 1u 0 1.1u 0 9u 0 9.1u 0 10u 0)
V_PIXEL_24 pixel_24 0 PWL(0 0 1u 0 1.1u 0 9u 0 9.1u 0 10u 0)
V_PIXEL_25 pixel_25 0 PWL(0 0 1u 0 1.1u 0 9u 0 9.1u 0 10u 0)
V_PIXEL_26 pixel_26 0 PWL(0 0 1u 0 1.1u 0.054509806632995608 9u 0.054509806632995608 9.1u 0 10u 0)
V_PIXEL_27 pixel_27 0 PWL(0 0 1u 0 1.1u 0.049019607901573184 9u 0.049019607901573184 9.1u 0 10u 0)
V_PIXEL_28 pixel_28 0 PWL(0 0 1u 0 1.1u 0.05764706134796143 9u 0.05764706134796143 9.1u 0 10u 0)
V_PIXEL_29 pixel_29 0 PWL(0 0 1u 0 1.1u 0.024705882370471957 9u 0.024705882370471957 9.1u 0 10u 0)
V_PIXEL_30 pixel_30 0 PWL(0 0 1u 0 1.1u 0 9u 0 9.1u 0 10u 0)
V_PIXEL_31 pixel_31 0 PWL(0 0 1u 0 1.1u 0 9u 0 9.1u 0 10u 0)
V_PIXEL_32 pixel_32 0 PWL(0 0 1u 0 1.1u 0 9u 0 9.1u 0 10u 0)
V_PIXEL_33 pixel_33 0 PWL(0 0 1u 0 1.1u 0 9u 0 9.1u 0 10u 0)
V_PIXEL_34 pixel_34 0 PWL(0 0 1u 0 1.1u 0 9u 0 9.1u 0 10u 0)
V_PIXEL_35 pixel_35 0 PWL(0 0 1u 0 1.1u 0 9u 0 9.1u 0 10u 0)
V_PIXEL_36 pixel_36 0 PWL(0 0 1u 0 1.1u 0 9u 0 9.1u 0 10u 0)
V_PIXEL_37 pixel_37 0 PWL(0 0 1u 0 1.1u 0.027450981736183169 9u 0.027450981736183169 9.1u 0 10u 0)
V_PIXEL_38 pixel_38 0 PWL(0 0 1u 0 1.1u 0.034509804844856266 9u 0.034509804844856266 9.1u 0 10u 0)
V_PIXEL_39 pixel_39 0 PWL(0 0 1u 0 1.1u 0 9u 0 9.1u 0 10u 0)
V_PIXEL_40 pixel_40 0 PWL(0 0 1u 0 1.1u 0 9u 0 9.1u 0 10u 0)
V_PIXEL_41 pixel_41 0 PWL(0 0 1u 0 1.1u 0 9u 0 9.1u 0 10u 0)
V_PIXEL_42 pixel_42 0 PWL(0 0 1u 0 1.1u 0.006666667014360428 9u 0.006666667014360428 9.1u 0 10u 0)
V_PIXEL_43 pixel_43 0 PWL(0 0 1u 0 1.1u 0 9u 0 9.1u 0 10u 0)
V_PIXEL_44 pixel_44 0 PWL(0 0 1u 0 1.1u 0 9u 0 9.1u 0 10u 0)
V_PIXEL_45 pixel_45 0 PWL(0 0 1u 0 1.1u 0.0011764706112444403 9u 0.0011764706112444403 9.1u 0 10u 0)
V_PIXEL_46 pixel_46 0 PWL(0 0 1u 0 1.1u 0.044313725829124455 9u 0.044313725829124455 9.1u 0 10u 0)
V_PIXEL_47 pixel_47 0 PWL(0 0 1u 0 1.1u 0 9u 0 9.1u 0 10u 0)
V_PIXEL_48 pixel_48 0 PWL(0 0 1u 0 1.1u 0 9u 0 9.1u 0 10u 0)
V_PIXEL_49 pixel_49 0 PWL(0 0 1u 0 1.1u 0 9u 0 9.1u 0 10u 0)
V_PIXEL_50 pixel_50 0 PWL(0 0 1u 0 1.1u 0.041176471114158633 9u 0.041176471114158633 9.1u 0 10u 0)
V_PIXEL_51 pixel_51 0 PWL(0 0 1u 0 1.1u 0.039215686917304995 9u 0.039215686917304995 9.1u 0 10u 0)
V_PIXEL_52 pixel_52 0 PWL(0 0 1u 0 1.1u 0.038823530077934265 9u 0.038823530077934265 9.1u 0 10u 0)
V_PIXEL_53 pixel_53 0 PWL(0 0 1u 0 1.1u 0.038823530077934265 9u 0.038823530077934265 9.1u 0 10u 0)
V_PIXEL_54 pixel_54 0 PWL(0 0 1u 0 1.1u 0.0078431375324726112 9u 0.0078431375324726112 9.1u 0 10u 0)
V_PIXEL_55 pixel_55 0 PWL(0 0 1u 0 1.1u 0 9u 0 9.1u 0 10u 0)
V_PIXEL_56 pixel_56 0 PWL(0 0 1u 0 1.1u 0 9u 0 9.1u 0 10u 0)
V_PIXEL_57 pixel_57 0 PWL(0 0 1u 0 1.1u 0 9u 0 9.1u 0 10u 0)
V_PIXEL_58 pixel_58 0 PWL(0 0 1u 0 1.1u 0 9u 0 9.1u 0 10u 0)
V_PIXEL_59 pixel_59 0 PWL(0 0 1u 0 1.1u 0 9u 0 9.1u 0 10u 0)
V_PIXEL_60 pixel_60 0 PWL(0 0 1u 0 1.1u 0 9u 0 9.1u 0 10u 0)
V_PIXEL_61 pixel_61 0 PWL(0 0 1u 0 1.1u 0 9u 0 9.1u 0 10u 0)
V_PIXEL_62 pixel_62 0 PWL(0 0 1u 0 1.1u 0 9u 0 9.1u 0 10u 0)
V_PIXEL_63 pixel_63 0 PWL(0 0 1u 0 1.1u 0 9u 0 9.1u 0 10u 0)
* Layer 1: 64 rows, 100 physical columns, 50 logical outputs
R_L1_p_0_0 pixel_0 l1_psum_0 1000000
R_L1_p_1_0 pixel_1 l1_psum_0 1000000
R_L1_p_2_0 pixel_2 l1_psum_0 1000000
R_L1_p_3_0 pixel_3 l1_psum_0 1000000
R_L1_p_4_0 pixel_4 l1_psum_0 1000000
R_L1_p_5_0 pixel_5 l1_psum_0 175000.00000000003
R_L1_p_6_0 pixel_6 l1_psum_0 1000000
R_L1_p_7_0 pixel_7 l1_psum_0 1000000
R_L1_p_8_0 pixel_8 l1_psum_0 1000000
R_L1_p_9_0 pixel_9 l1_psum_0 1000000
R_L1_p_10_0 pixel_10 l1_psum_0 1000000
R_L1_p_11_0 pixel_11 l1_psum_0 1000000
R_L1_p_12_0 pixel_12 l1_psum_0 388888.88888888888
R_L1_p_13_0 pixel_13 l1_psum_0 83333.333333333328
R_L1_p_14_0 pixel_14 l1_psum_0 59829.059829059821
R_L1_p_15_0 pixel_15 l1_psum_0 241379.31034482759
R_L1_p_16_0 pixel_16 l1_psum_0 112903.22580645159
R_L1_p_17_0 pixel_17 l1_psum_0 1000000
R_L1_p_18_0 pixel_18 l1_psum_0 137254.90196078431
R_L1_p_19_0 pixel_19 l1_psum_0 175000.00000000003
R_L1_p_20_0 pixel_20 l1_psum_0 1000000
R_L1_p_21_0 pixel_21 l1_psum_0 1000000
R_L1_p_22_0 pixel_22 l1_psum_0 21472.39263803681
R_L1_p_23_0 pixel_23 l1_psum_0 137254.90196078431
R_L1_p_24_0 pixel_24 l1_psum_0 54687.499999999993
R_L1_p_25_0 pixel_25 l1_psum_0 241379.31034482759
R_L1_p_26_0 pixel_26 l1_psum_0 1000000
R_L1_p_27_0 pixel_27 l1_psum_0 1000000
R_L1_p_28_0 pixel_28 l1_psum_0 1000000
R_L1_p_29_0 pixel_29 l1_psum_0 26923.076923076922
R_L1_p_30_0 pixel_30 l1_psum_0 36082.474226804123
R_L1_p_31_0 pixel_31 l1_psum_0 1000000
R_L1_p_32_0 pixel_32 l1_psum_0 40697.674418604649
R_L1_p_33_0 pixel_33 l1_psum_0 1000000
R_L1_p_34_0 pixel_34 l1_psum_0 241379.31034482759
R_L1_p_35_0 pixel_35 l1_psum_0 73684.210526315786
R_L1_p_36_0 pixel_36 l1_psum_0 59829.059829059821
R_L1_p_37_0 pixel_37 l1_psum_0 50359.712230215831
R_L1_p_38_0 pixel_38 l1_psum_0 241379.31034482759
R_L1_p_39_0 pixel_39 l1_psum_0 1000000
R_L1_p_40_0 pixel_40 l1_psum_0 1000000
R_L1_p_41_0 pixel_41 l1_psum_0 83333.333333333328
R_L1_p_42_0 pixel_42 l1_psum_0 1000000
R_L1_p_43_0 pixel_43 l1_psum_0 83333.333333333328
R_L1_p_44_0 pixel_44 l1_psum_0 95890.410958904104
R_L1_p_45_0 pixel_45 l1_psum_0 1000000
R_L1_p_46_0 pixel_46 l1_psum_0 175000.00000000003
R_L1_p_47_0 pixel_47 l1_psum_0 1000000
R_L1_p_48_0 pixel_48 l1_psum_0 1000000
R_L1_p_49_0 pixel_49 l1_psum_0 59829.059829059821
R_L1_p_50_0 pixel_50 l1_psum_0 388888.88888888888
R_L1_p_51_0 pixel_51 l1_psum_0 137254.90196078431
R_L1_p_52_0 pixel_52 l1_psum_0 1000000
R_L1_p_53_0 pixel_53 l1_psum_0 241379.31034482759
R_L1_p_54_0 pixel_54 l1_psum_0 95890.410958904104
R_L1_p_55_0 pixel_55 l1_psum_0 1000000
R_L1_p_56_0 pixel_56 l1_psum_0 1000000
R_L1_p_57_0 pixel_57 l1_psum_0 66037.735849056597
R_L1_p_58_0 pixel_58 l1_psum_0 137254.90196078431
R_L1_p_59_0 pixel_59 l1_psum_0 34146.341463414632
R_L1_p_60_0 pixel_60 l1_psum_0 43478.260869565216
R_L1_p_61_0 pixel_61 l1_psum_0 95890.410958904104
R_L1_p_62_0 pixel_62 l1_psum_0 1000000
R_L1_p_63_0 pixel_63 l1_psum_0 83333.333333333328
E_TIA_L1_p_0 l1_pout_0 0 0 l1_psum_0 100000000
R_FB_L1_p_0 l1_pout_0 l1_psum_0 1000
R_L1_m_0_0 pixel_0 l1_msum_0 54687.499999999993
R_L1_m_1_0 pixel_1 l1_msum_0 43478.260869565216
R_L1_m_2_0 pixel_2 l1_msum_0 30837.004405286345
R_L1_m_3_0 pixel_3 l1_msum_0 21472.39263803681
R_L1_m_4_0 pixel_4 l1_msum_0 54687.499999999993
R_L1_m_5_0 pixel_5 l1_msum_0 1000000
R_L1_m_6_0 pixel_6 l1_msum_0 388888.88888888888
R_L1_m_7_0 pixel_7 l1_msum_0 59829.059829059821
R_L1_m_8_0 pixel_8 l1_msum_0 40697.674418604649
R_L1_m_9_0 pixel_9 l1_msum_0 73684.210526315786
R_L1_m_10_0 pixel_10 l1_msum_0 73684.210526315786
R_L1_m_11_0 pixel_11 l1_msum_0 112903.22580645159
R_L1_m_12_0 pixel_12 l1_msum_0 1000000
R_L1_m_13_0 pixel_13 l1_msum_0 1000000
R_L1_m_14_0 pixel_14 l1_msum_0 1000000
R_L1_m_15_0 pixel_15 l1_msum_0 1000000
R_L1_m_16_0 pixel_16 l1_msum_0 1000000
R_L1_m_17_0 pixel_17 l1_msum_0 241379.31034482759
R_L1_m_18_0 pixel_18 l1_msum_0 1000000
R_L1_m_19_0 pixel_19 l1_msum_0 1000000
R_L1_m_20_0 pixel_20 l1_msum_0 36082.474226804123
R_L1_m_21_0 pixel_21 l1_msum_0 388888.88888888888
R_L1_m_22_0 pixel_22 l1_msum_0 1000000
R_L1_m_23_0 pixel_23 l1_msum_0 1000000
R_L1_m_24_0 pixel_24 l1_msum_0 1000000
R_L1_m_25_0 pixel_25 l1_msum_0 1000000
R_L1_m_26_0 pixel_26 l1_msum_0 66037.735849056597
R_L1_m_27_0 pixel_27 l1_msum_0 32407.407407407409
R_L1_m_28_0 pixel_28 l1_msum_0 21472.39263803681
R_L1_m_29_0 pixel_29 l1_msum_0 1000000
R_L1_m_30_0 pixel_30 l1_msum_0 1000000
R_L1_m_31_0 pixel_31 l1_msum_0 1000000
R_L1_m_32_0 pixel_32 l1_msum_0 1000000
R_L1_m_33_0 pixel_33 l1_msum_0 95890.410958904104
R_L1_m_34_0 pixel_34 l1_msum_0 1000000
R_L1_m_35_0 pixel_35 l1_msum_0 1000000
R_L1_m_36_0 pixel_36 l1_msum_0 1000000
R_L1_m_37_0 pixel_37 l1_msum_0 1000000
R_L1_m_38_0 pixel_38 l1_msum_0 1000000
R_L1_m_39_0 pixel_39 l1_msum_0 17857.142857142859
R_L1_m_40_0 pixel_40 l1_msum_0 1000000
R_L1_m_41_0 pixel_41 l1_msum_0 1000000
R_L1_m_42_0 pixel_42 l1_msum_0 388888.88888888888
R_L1_m_43_0 pixel_43 l1_msum_0 1000000
R_L1_m_44_0 pixel_44 l1_msum_0 1000000
R_L1_m_45_0 pixel_45 l1_msum_0 54687.499999999993
R_L1_m_46_0 pixel_46 l1_msum_0 1000000
R_L1_m_47_0 pixel_47 l1_msum_0 66037.735849056597
R_L1_m_48_0 pixel_48 l1_msum_0 40697.674418604649
R_L1_m_49_0 pixel_49 l1_msum_0 1000000
R_L1_m_50_0 pixel_50 l1_msum_0 1000000
R_L1_m_51_0 pixel_51 l1_msum_0 1000000
R_L1_m_52_0 pixel_52 l1_msum_0 112903.22580645159
R_L1_m_53_0 pixel_53 l1_msum_0 1000000
R_L1_m_54_0 pixel_54 l1_msum_0 1000000
R_L1_m_55_0 pixel_55 l1_msum_0 83333.333333333328
R_L1_m_56_0 pixel_56 l1_msum_0 38251.366120218576
R_L1_m_57_0 pixel_57 l1_msum_0 1000000
R_L1_m_58_0 pixel_58 l1_msum_0 1000000
R_L1_m_59_0 pixel_59 l1_msum_0 1000000
R_L1_m_60_0 pixel_60 l1_msum_0 1000000
R_L1_m_61_0 pixel_61 l1_msum_0 1000000
R_L1_m_62_0 pixel_62 l1_msum_0 50359.712230215831
R_L1_m_63_0 pixel_63 l1_msum_0 1000000
E_TIA_L1_m_0 l1_mout_0 0 0 l1_msum_0 100000000
R_FB_L1_m_0 l1_mout_0 l1_msum_0 1000
B_NEURON_L1_0 hidden_0 0 V={0.01*max(((V(l1_mout_0)-V(l1_pout_0))/0.0030903275574088963+(-0.040358103811740875)),0)}
R_L1_p_0_1 pixel_0 l1_psum_1 1000000
R_L1_p_1_1 pixel_1 l1_psum_1 137254.90196078431
R_L1_p_2_1 pixel_2 l1_psum_1 1000000
R_L1_p_3_1 pixel_3 l1_psum_1 1000000
R_L1_p_4_1 pixel_4 l1_psum_1 1000000
R_L1_p_5_1 pixel_5 l1_psum_1 54687.499999999993
R_L1_p_6_1 pixel_6 l1_psum_1 43478.260869565216
R_L1_p_7_1 pixel_7 l1_psum_1 1000000
R_L1_p_8_1 pixel_8 l1_psum_1 175000.00000000003
R_L1_p_9_1 pixel_9 l1_psum_1 1000000
R_L1_p_10_1 pixel_10 l1_psum_1 1000000
R_L1_p_11_1 pixel_11 l1_psum_1 1000000
R_L1_p_12_1 pixel_12 l1_psum_1 1000000
R_L1_p_13_1 pixel_13 l1_psum_1 137254.90196078431
R_L1_p_14_1 pixel_14 l1_psum_1 46666.666666666664
R_L1_p_15_1 pixel_15 l1_psum_1 43478.260869565216
R_L1_p_16_1 pixel_16 l1_psum_1 1000000
R_L1_p_17_1 pixel_17 l1_psum_1 1000000
R_L1_p_18_1 pixel_18 l1_psum_1 66037.735849056597
R_L1_p_19_1 pixel_19 l1_psum_1 95890.410958904104
R_L1_p_20_1 pixel_20 l1_psum_1 1000000
R_L1_p_21_1 pixel_21 l1_psum_1 1000000
R_L1_p_22_1 pixel_22 l1_psum_1 1000000
R_L1_p_23_1 pixel_23 l1_psum_1 66037.735849056597
R_L1_p_24_1 pixel_24 l1_psum_1 1000000
R_L1_p_25_1 pixel_25 l1_psum_1 241379.31034482759
R_L1_p_26_1 pixel_26 l1_psum_1 50359.712230215831
R_L1_p_27_1 pixel_27 l1_psum_1 95890.410958904104
R_L1_p_28_1 pixel_28 l1_psum_1 1000000
R_L1_p_29_1 pixel_29 l1_psum_1 1000000
R_L1_p_30_1 pixel_30 l1_psum_1 1000000
R_L1_p_31_1 pixel_31 l1_psum_1 1000000
R_L1_p_32_1 pixel_32 l1_psum_1 1000000
R_L1_p_33_1 pixel_33 l1_psum_1 83333.333333333328
R_L1_p_34_1 pixel_34 l1_psum_1 66037.735849056597
R_L1_p_35_1 pixel_35 l1_psum_1 1000000
R_L1_p_36_1 pixel_36 l1_psum_1 137254.90196078431
R_L1_p_37_1 pixel_37 l1_psum_1 43478.260869565216
R_L1_p_38_1 pixel_38 l1_psum_1 137254.90196078431
R_L1_p_39_1 pixel_39 l1_psum_1 1000000
R_L1_p_40_1 pixel_40 l1_psum_1 1000000
R_L1_p_41_1 pixel_41 l1_psum_1 175000.00000000003
R_L1_p_42_1 pixel_42 l1_psum_1 1000000
R_L1_p_43_1 pixel_43 l1_psum_1 1000000
R_L1_p_44_1 pixel_44 l1_psum_1 388888.88888888888
R_L1_p_45_1 pixel_45 l1_psum_1 1000000
R_L1_p_46_1 pixel_46 l1_psum_1 1000000
R_L1_p_47_1 pixel_47 l1_psum_1 1000000
R_L1_p_48_1 pixel_48 l1_psum_1 1000000
R_L1_p_49_1 pixel_49 l1_psum_1 1000000
R_L1_p_50_1 pixel_50 l1_psum_1 1000000
R_L1_p_51_1 pixel_51 l1_psum_1 73684.210526315786
R_L1_p_52_1 pixel_52 l1_psum_1 59829.059829059821
R_L1_p_53_1 pixel_53 l1_psum_1 66037.735849056597
R_L1_p_54_1 pixel_54 l1_psum_1 175000.00000000003
R_L1_p_55_1 pixel_55 l1_psum_1 1000000
R_L1_p_56_1 pixel_56 l1_psum_1 36082.474226804123
R_L1_p_57_1 pixel_57 l1_psum_1 1000000
R_L1_p_58_1 pixel_58 l1_psum_1 1000000
R_L1_p_59_1 pixel_59 l1_psum_1 388888.88888888888
R_L1_p_60_1 pixel_60 l1_psum_1 1000000
R_L1_p_61_1 pixel_61 l1_psum_1 1000000
R_L1_p_62_1 pixel_62 l1_psum_1 175000.00000000003
R_L1_p_63_1 pixel_63 l1_psum_1 1000000
E_TIA_L1_p_1 l1_pout_1 0 0 l1_psum_1 100000000
R_FB_L1_p_1 l1_pout_1 l1_psum_1 1000
R_L1_m_0_1 pixel_0 l1_msum_1 83333.333333333328
R_L1_m_1_1 pixel_1 l1_msum_1 1000000
R_L1_m_2_1 pixel_2 l1_msum_1 43478.260869565216
R_L1_m_3_1 pixel_3 l1_msum_1 54687.499999999993
R_L1_m_4_1 pixel_4 l1_msum_1 83333.333333333328
R_L1_m_5_1 pixel_5 l1_msum_1 1000000
R_L1_m_6_1 pixel_6 l1_msum_1 1000000
R_L1_m_7_1 pixel_7 l1_msum_1 54687.499999999993
R_L1_m_8_1 pixel_8 l1_msum_1 1000000
R_L1_m_9_1 pixel_9 l1_msum_1 54687.499999999993
R_L1_m_10_1 pixel_10 l1_msum_1 388888.88888888888
R_L1_m_11_1 pixel_11 l1_msum_1 83333.333333333328
R_L1_m_12_1 pixel_12 l1_msum_1 388888.88888888888
R_L1_m_13_1 pixel_13 l1_msum_1 1000000
R_L1_m_14_1 pixel_14 l1_msum_1 1000000
R_L1_m_15_1 pixel_15 l1_msum_1 1000000
R_L1_m_16_1 pixel_16 l1_msum_1 46666.666666666664
R_L1_m_17_1 pixel_17 l1_msum_1 175000.00000000003
R_L1_m_18_1 pixel_18 l1_msum_1 1000000
R_L1_m_19_1 pixel_19 l1_msum_1 1000000
R_L1_m_20_1 pixel_20 l1_msum_1 137254.90196078431
R_L1_m_21_1 pixel_21 l1_msum_1 95890.410958904104
R_L1_m_22_1 pixel_22 l1_msum_1 38251.366120218576
R_L1_m_23_1 pixel_23 l1_msum_1 1000000
R_L1_m_24_1 pixel_24 l1_msum_1 66037.735849056597
R_L1_m_25_1 pixel_25 l1_msum_1 1000000
R_L1_m_26_1 pixel_26 l1_msum_1 1000000
R_L1_m_27_1 pixel_27 l1_msum_1 1000000
R_L1_m_28_1 pixel_28 l1_msum_1 95890.410958904104
R_L1_m_29_1 pixel_29 l1_msum_1 1000000
R_L1_m_30_1 pixel_30 l1_msum_1 137254.90196078431
R_L1_m_31_1 pixel_31 l1_msum_1 23026.315789473687
R_L1_m_32_1 pixel_32 l1_msum_1 50359.712230215831
R_L1_m_33_1 pixel_33 l1_msum_1 1000000
R_L1_m_34_1 pixel_34 l1_msum_1 1000000
R_L1_m_35_1 pixel_35 l1_msum_1 175000.00000000003
R_L1_m_36_1 pixel_36 l1_msum_1 1000000
R_L1_m_37_1 pixel_37 l1_msum_1 1000000
R_L1_m_38_1 pixel_38 l1_msum_1 1000000
R_L1_m_39_1 pixel_39 l1_msum_1 20771.51335311573
R_L1_m_40_1 pixel_40 l1_msum_1 175000.00000000003
R_L1_m_41_1 pixel_41 l1_msum_1 1000000
R_L1_m_42_1 pixel_42 l1_msum_1 241379.31034482759
R_L1_m_43_1 pixel_43 l1_msum_1 1000000
R_L1_m_44_1 pixel_44 l1_msum_1 1000000
R_L1_m_45_1 pixel_45 l1_msum_1 388888.88888888888
R_L1_m_46_1 pixel_46 l1_msum_1 66037.735849056597
R_L1_m_47_1 pixel_47 l1_msum_1 43478.260869565216
R_L1_m_48_1 pixel_48 l1_msum_1 54687.499999999993
R_L1_m_49_1 pixel_49 l1_msum_1 26923.076923076922
R_L1_m_50_1 pixel_50 l1_msum_1 24822.695035460994
R_L1_m_51_1 pixel_51 l1_msum_1 1000000
R_L1_m_52_1 pixel_52 l1_msum_1 1000000
R_L1_m_53_1 pixel_53 l1_msum_1 1000000
R_L1_m_54_1 pixel_54 l1_msum_1 1000000
R_L1_m_55_1 pixel_55 l1_msum_1 137254.90196078431
R_L1_m_56_1 pixel_56 l1_msum_1 1000000
R_L1_m_57_1 pixel_57 l1_msum_1 83333.333333333328
R_L1_m_58_1 pixel_58 l1_msum_1 112903.22580645159
R_L1_m_59_1 pixel_59 l1_msum_1 1000000
R_L1_m_60_1 pixel_60 l1_msum_1 137254.90196078431
R_L1_m_61_1 pixel_61 l1_msum_1 66037.735849056597
R_L1_m_62_1 pixel_62 l1_msum_1 1000000
R_L1_m_63_1 pixel_63 l1_msum_1 112903.22580645159
E_TIA_L1_m_1 l1_mout_1 0 0 l1_msum_1 100000000
R_FB_L1_m_1 l1_mout_1 l1_msum_1 1000
B_NEURON_L1_1 hidden_1 0 V={0.01*max(((V(l1_mout_1)-V(l1_pout_1))/0.0030903275574088963+(-0.023910798132419586)),0)}
R_L1_p_0_2 pixel_0 l1_psum_2 137254.90196078431
R_L1_p_1_2 pixel_1 l1_psum_2 40697.674418604649
R_L1_p_2_2 pixel_2 l1_psum_2 54687.499999999993
R_L1_p_3_2 pixel_3 l1_psum_2 175000.00000000003
R_L1_p_4_2 pixel_4 l1_psum_2 95890.410958904104
R_L1_p_5_2 pixel_5 l1_psum_2 32407.407407407409
R_L1_p_6_2 pixel_6 l1_psum_2 17369.727047146403
R_L1_p_7_2 pixel_7 l1_psum_2 1000000
R_L1_p_8_2 pixel_8 l1_psum_2 73684.210526315786
R_L1_p_9_2 pixel_9 l1_psum_2 73684.210526315786
R_L1_p_10_2 pixel_10 l1_psum_2 54687.499999999993
R_L1_p_11_2 pixel_11 l1_psum_2 1000000
R_L1_p_12_2 pixel_12 l1_psum_2 1000000
R_L1_p_13_2 pixel_13 l1_psum_2 1000000
R_L1_p_14_2 pixel_14 l1_psum_2 54687.499999999993
R_L1_p_15_2 pixel_15 l1_psum_2 28112.449799196787
R_L1_p_16_2 pixel_16 l1_psum_2 112903.22580645159
R_L1_p_17_2 pixel_17 l1_psum_2 137254.90196078431
R_L1_p_18_2 pixel_18 l1_psum_2 43478.260869565216
R_L1_p_19_2 pixel_19 l1_psum_2 1000000
R_L1_p_20_2 pixel_20 l1_psum_2 1000000
R_L1_p_21_2 pixel_21 l1_psum_2 1000000
R_L1_p_22_2 pixel_22 l1_psum_2 1000000
R_L1_p_23_2 pixel_23 l1_psum_2 43478.260869565216
R_L1_p_24_2 pixel_24 l1_psum_2 241379.31034482759
R_L1_p_25_2 pixel_25 l1_psum_2 388888.88888888888
R_L1_p_26_2 pixel_26 l1_psum_2 50359.712230215831
R_L1_p_27_2 pixel_27 l1_psum_2 73684.210526315786
R_L1_p_28_2 pixel_28 l1_psum_2 175000.00000000003
R_L1_p_29_2 pixel_29 l1_psum_2 112903.22580645159
R_L1_p_30_2 pixel_30 l1_psum_2 241379.31034482759
R_L1_p_31_2 pixel_31 l1_psum_2 1000000
R_L1_p_32_2 pixel_32 l1_psum_2 1000000
R_L1_p_33_2 pixel_33 l1_psum_2 1000000
R_L1_p_34_2 pixel_34 l1_psum_2 388888.88888888888
R_L1_p_35_2 pixel_35 l1_psum_2 73684.210526315786
R_L1_p_36_2 pixel_36 l1_psum_2 73684.210526315786
R_L1_p_37_2 pixel_37 l1_psum_2 1000000
R_L1_p_38_2 pixel_38 l1_psum_2 66037.735849056597
R_L1_p_39_2 pixel_39 l1_psum_2 1000000
R_L1_p_40_2 pixel_40 l1_psum_2 1000000
R_L1_p_41_2 pixel_41 l1_psum_2 1000000
R_L1_p_42_2 pixel_42 l1_psum_2 1000000
R_L1_p_43_2 pixel_43 l1_psum_2 112903.22580645159
R_L1_p_44_2 pixel_44 l1_psum_2 1000000
R_L1_p_45_2 pixel_45 l1_psum_2 137254.90196078431
R_L1_p_46_2 pixel_46 l1_psum_2 66037.735849056597
R_L1_p_47_2 pixel_47 l1_psum_2 1000000
R_L1_p_48_2 pixel_48 l1_psum_2 83333.333333333328
R_L1_p_49_2 pixel_49 l1_psum_2 1000000
R_L1_p_50_2 pixel_50 l1_psum_2 1000000
R_L1_p_51_2 pixel_51 l1_psum_2 137254.90196078431
R_L1_p_52_2 pixel_52 l1_psum_2 59829.059829059821
R_L1_p_53_2 pixel_53 l1_psum_2 73684.210526315786
R_L1_p_54_2 pixel_54 l1_psum_2 1000000
R_L1_p_55_2 pixel_55 l1_psum_2 1000000
R_L1_p_56_2 pixel_56 l1_psum_2 50359.712230215831
R_L1_p_57_2 pixel_57 l1_psum_2 1000000
R_L1_p_58_2 pixel_58 l1_psum_2 1000000
R_L1_p_59_2 pixel_59 l1_psum_2 1000000
R_L1_p_60_2 pixel_60 l1_psum_2 1000000
R_L1_p_61_2 pixel_61 l1_psum_2 1000000
R_L1_p_62_2 pixel_62 l1_psum_2 241379.31034482759
R_L1_p_63_2 pixel_63 l1_psum_2 1000000
E_TIA_L1_p_2 l1_pout_2 0 0 l1_psum_2 100000000
R_FB_L1_p_2 l1_pout_2 l1_psum_2 1000
R_L1_m_0_2 pixel_0 l1_msum_2 1000000
R_L1_m_1_2 pixel_1 l1_msum_2 1000000
R_L1_m_2_2 pixel_2 l1_msum_2 1000000
R_L1_m_3_2 pixel_3 l1_msum_2 1000000
R_L1_m_4_2 pixel_4 l1_msum_2 1000000
R_L1_m_5_2 pixel_5 l1_msum_2 1000000
R_L1_m_6_2 pixel_6 l1_msum_2 1000000
R_L1_m_7_2 pixel_7 l1_msum_2 46666.666666666664
R_L1_m_8_2 pixel_8 l1_msum_2 1000000
R_L1_m_9_2 pixel_9 l1_msum_2 1000000
R_L1_m_10_2 pixel_10 l1_msum_2 1000000
R_L1_m_11_2 pixel_11 l1_msum_2 73684.210526315786
R_L1_m_12_2 pixel_12 l1_msum_2 50359.712230215831
R_L1_m_13_2 pixel_13 l1_msum_2 175000.00000000003
R_L1_m_14_2 pixel_14 l1_msum_2 1000000
R_L1_m_15_2 pixel_15 l1_msum_2 1000000
R_L1_m_16_2 pixel_16 l1_msum_2 1000000
R_L1_m_17_2 pixel_17 l1_msum_2 1000000
R_L1_m_18_2 pixel_18 l1_msum_2 1000000
R_L1_m_19_2 pixel_19 l1_msum_2 54687.499999999993
R_L1_m_20_2 pixel_20 l1_msum_2 28112.449799196787
R_L1_m_21_2 pixel_21 l1_msum_2 40697.674418604649
R_L1_m_22_2 pixel_22 l1_msum_2 83333.333333333328
R_L1_m_23_2 pixel_23 l1_msum_2 1000000
R_L1_m_24_2 pixel_24 l1_msum_2 1000000
R_L1_m_25_2 pixel_25 l1_msum_2 1000000
R_L1_m_26_2 pixel_26 l1_msum_2 1000000
R_L1_m_27_2 pixel_27 l1_msum_2 1000000
R_L1_m_28_2 pixel_28 l1_msum_2 1000000
R_L1_m_29_2 pixel_29 l1_msum_2 1000000
R_L1_m_30_2 pixel_30 l1_msum_2 1000000
R_L1_m_31_2 pixel_31 l1_msum_2 43478.260869565216
R_L1_m_32_2 pixel_32 l1_msum_2 73684.210526315786
R_L1_m_33_2 pixel_33 l1_msum_2 112903.22580645159
R_L1_m_34_2 pixel_34 l1_msum_2 1000000
R_L1_m_35_2 pixel_35 l1_msum_2 1000000
R_L1_m_36_2 pixel_36 l1_msum_2 1000000
R_L1_m_37_2 pixel_37 l1_msum_2 1000000
R_L1_m_38_2 pixel_38 l1_msum_2 1000000
R_L1_m_39_2 pixel_39 l1_msum_2 54687.499999999993
R_L1_m_40_2 pixel_40 l1_msum_2 34146.341463414632
R_L1_m_41_2 pixel_41 l1_msum_2 1000000
R_L1_m_42_2 pixel_42 l1_msum_2 95890.410958904104
R_L1_m_43_2 pixel_43 l1_msum_2 1000000
R_L1_m_44_2 pixel_44 l1_msum_2 241379.31034482759
R_L1_m_45_2 pixel_45 l1_msum_2 1000000
R_L1_m_46_2 pixel_46 l1_msum_2 1000000
R_L1_m_47_2 pixel_47 l1_msum_2 21472.39263803681
R_L1_m_48_2 pixel_48 l1_msum_2 1000000
R_L1_m_49_2 pixel_49 l1_msum_2 66037.735849056597
R_L1_m_50_2 pixel_50 l1_msum_2 112903.22580645159
R_L1_m_51_2 pixel_51 l1_msum_2 1000000
R_L1_m_52_2 pixel_52 l1_msum_2 1000000
R_L1_m_53_2 pixel_53 l1_msum_2 1000000
R_L1_m_54_2 pixel_54 l1_msum_2 83333.333333333328
R_L1_m_55_2 pixel_55 l1_msum_2 20114.942528735632
R_L1_m_56_2 pixel_56 l1_msum_2 1000000
R_L1_m_57_2 pixel_57 l1_msum_2 1000000
R_L1_m_58_2 pixel_58 l1_msum_2 32407.407407407409
R_L1_m_59_2 pixel_59 l1_msum_2 59829.059829059821
R_L1_m_60_2 pixel_60 l1_msum_2 137254.90196078431
R_L1_m_61_2 pixel_61 l1_msum_2 40697.674418604649
R_L1_m_62_2 pixel_62 l1_msum_2 1000000
R_L1_m_63_2 pixel_63 l1_msum_2 241379.31034482759
E_TIA_L1_m_2 l1_mout_2 0 0 l1_msum_2 100000000
R_FB_L1_m_2 l1_mout_2 l1_msum_2 1000
B_NEURON_L1_2 hidden_2 0 V={0.01*max(((V(l1_mout_2)-V(l1_pout_2))/0.0030903275574088963+(0.18145176768302917)),0)}
R_L1_p_0_3 pixel_0 l1_psum_3 1000000
R_L1_p_1_3 pixel_1 l1_psum_3 95890.410958904104
R_L1_p_2_3 pixel_2 l1_psum_3 137254.90196078431
R_L1_p_3_3 pixel_3 l1_psum_3 1000000
R_L1_p_4_3 pixel_4 l1_psum_3 38251.366120218576
R_L1_p_5_3 pixel_5 l1_psum_3 54687.499999999993
R_L1_p_6_3 pixel_6 l1_psum_3 388888.88888888888
R_L1_p_7_3 pixel_7 l1_psum_3 1000000
R_L1_p_8_3 pixel_8 l1_psum_3 388888.88888888888
R_L1_p_9_3 pixel_9 l1_psum_3 1000000
R_L1_p_10_3 pixel_10 l1_psum_3 112903.22580645159
R_L1_p_11_3 pixel_11 l1_psum_3 388888.88888888888
R_L1_p_12_3 pixel_12 l1_psum_3 83333.333333333328
R_L1_p_13_3 pixel_13 l1_psum_3 54687.499999999993
R_L1_p_14_3 pixel_14 l1_psum_3 95890.410958904104
R_L1_p_15_3 pixel_15 l1_psum_3 59829.059829059821
R_L1_p_16_3 pixel_16 l1_psum_3 1000000
R_L1_p_17_3 pixel_17 l1_psum_3 241379.31034482759
R_L1_p_18_3 pixel_18 l1_psum_3 36082.474226804123
R_L1_p_19_3 pixel_19 l1_psum_3 1000000
R_L1_p_20_3 pixel_20 l1_psum_3 388888.88888888888
R_L1_p_21_3 pixel_21 l1_psum_3 1000000
R_L1_p_22_3 pixel_22 l1_psum_3 112903.22580645159
R_L1_p_23_3 pixel_23 l1_psum_3 28112.449799196787
R_L1_p_24_3 pixel_24 l1_psum_3 175000.00000000003
R_L1_p_25_3 pixel_25 l1_psum_3 1000000
R_L1_p_26_3 pixel_26 l1_psum_3 1000000
R_L1_p_27_3 pixel_27 l1_psum_3 73684.210526315786
R_L1_p_28_3 pixel_28 l1_psum_3 95890.410958904104
R_L1_p_29_3 pixel_29 l1_psum_3 1000000
R_L1_p_30_3 pixel_30 l1_psum_3 1000000
R_L1_p_31_3 pixel_31 l1_psum_3 40697.674418604649
R_L1_p_32_3 pixel_32 l1_psum_3 388888.88888888888
R_L1_p_33_3 pixel_33 l1_psum_3 1000000
R_L1_p_34_3 pixel_34 l1_psum_3 1000000
R_L1_p_35_3 pixel_35 l1_psum_3 137254.90196078431
R_L1_p_36_3 pixel_36 l1_psum_3 1000000
R_L1_p_37_3 pixel_37 l1_psum_3 1000000
R_L1_p_38_3 pixel_38 l1_psum_3 46666.666666666664
R_L1_p_39_3 pixel_39 l1_psum_3 1000000
R_L1_p_40_3 pixel_40 l1_psum_3 83333.333333333328
R_L1_p_41_3 pixel_41 l1_psum_3 73684.210526315786
R_L1_p_42_3 pixel_42 l1_psum_3 1000000
R_L1_p_43_3 pixel_43 l1_psum_3 1000000
R_L1_p_44_3 pixel_44 l1_psum_3 1000000
R_L1_p_45_3 pixel_45 l1_psum_3 66037.735849056597
R_L1_p_46_3 pixel_46 l1_psum_3 43478.260869565216
R_L1_p_47_3 pixel_47 l1_psum_3 1000000
R_L1_p_48_3 pixel_48 l1_psum_3 1000000
R_L1_p_49_3 pixel_49 l1_psum_3 388888.88888888888
R_L1_p_50_3 pixel_50 l1_psum_3 175000.00000000003
R_L1_p_51_3 pixel_51 l1_psum_3 112903.22580645159
R_L1_p_52_3 pixel_52 l1_psum_3 36082.474226804123
R_L1_p_53_3 pixel_53 l1_psum_3 54687.499999999993
R_L1_p_54_3 pixel_54 l1_psum_3 388888.88888888888
R_L1_p_55_3 pixel_55 l1_psum_3 1000000
R_L1_p_56_3 pixel_56 l1_psum_3 137254.90196078431
R_L1_p_57_3 pixel_57 l1_psum_3 1000000
R_L1_p_58_3 pixel_58 l1_psum_3 43478.260869565216
R_L1_p_59_3 pixel_59 l1_psum_3 38251.366120218576
R_L1_p_60_3 pixel_60 l1_psum_3 175000.00000000003
R_L1_p_61_3 pixel_61 l1_psum_3 137254.90196078431
R_L1_p_62_3 pixel_62 l1_psum_3 137254.90196078431
R_L1_p_63_3 pixel_63 l1_psum_3 388888.88888888888
E_TIA_L1_p_3 l1_pout_3 0 0 l1_psum_3 100000000
R_FB_L1_p_3 l1_pout_3 l1_psum_3 1000
R_L1_m_0_3 pixel_0 l1_msum_3 241379.31034482759
R_L1_m_1_3 pixel_1 l1_msum_3 1000000
R_L1_m_2_3 pixel_2 l1_msum_3 1000000
R_L1_m_3_3 pixel_3 l1_msum_3 1000000
R_L1_m_4_3 pixel_4 l1_msum_3 1000000
R_L1_m_5_3 pixel_5 l1_msum_3 1000000
R_L1_m_6_3 pixel_6 l1_msum_3 1000000
R_L1_m_7_3 pixel_7 l1_msum_3 137254.90196078431
R_L1_m_8_3 pixel_8 l1_msum_3 1000000
R_L1_m_9_3 pixel_9 l1_msum_3 95890.410958904104
R_L1_m_10_3 pixel_10 l1_msum_3 1000000
R_L1_m_11_3 pixel_11 l1_msum_3 1000000
R_L1_m_12_3 pixel_12 l1_msum_3 1000000
R_L1_m_13_3 pixel_13 l1_msum_3 1000000
R_L1_m_14_3 pixel_14 l1_msum_3 1000000
R_L1_m_15_3 pixel_15 l1_msum_3 1000000
R_L1_m_16_3 pixel_16 l1_msum_3 1000000
R_L1_m_17_3 pixel_17 l1_msum_3 1000000
R_L1_m_18_3 pixel_18 l1_msum_3 1000000
R_L1_m_19_3 pixel_19 l1_msum_3 241379.31034482759
R_L1_m_20_3 pixel_20 l1_msum_3 1000000
R_L1_m_21_3 pixel_21 l1_msum_3 137254.90196078431
R_L1_m_22_3 pixel_22 l1_msum_3 1000000
R_L1_m_23_3 pixel_23 l1_msum_3 1000000
R_L1_m_24_3 pixel_24 l1_msum_3 1000000
R_L1_m_25_3 pixel_25 l1_msum_3 388888.88888888888
R_L1_m_26_3 pixel_26 l1_msum_3 388888.88888888888
R_L1_m_27_3 pixel_27 l1_msum_3 1000000
R_L1_m_28_3 pixel_28 l1_msum_3 1000000
R_L1_m_29_3 pixel_29 l1_msum_3 137254.90196078431
R_L1_m_30_3 pixel_30 l1_msum_3 20114.942528735632
R_L1_m_31_3 pixel_31 l1_msum_3 1000000
R_L1_m_32_3 pixel_32 l1_msum_3 1000000
R_L1_m_33_3 pixel_33 l1_msum_3 36082.474226804123
R_L1_m_34_3 pixel_34 l1_msum_3 46666.666666666664
R_L1_m_35_3 pixel_35 l1_msum_3 1000000
R_L1_m_36_3 pixel_36 l1_msum_3 95890.410958904104
R_L1_m_37_3 pixel_37 l1_msum_3 112903.22580645159
R_L1_m_38_3 pixel_38 l1_msum_3 1000000
R_L1_m_39_3 pixel_39 l1_msum_3 21472.39263803681
R_L1_m_40_3 pixel_40 l1_msum_3 1000000
R_L1_m_41_3 pixel_41 l1_msum_3 1000000
R_L1_m_42_3 pixel_42 l1_msum_3 59829.059829059821
R_L1_m_43_3 pixel_43 l1_msum_3 73684.210526315786
R_L1_m_44_3 pixel_44 l1_msum_3 137254.90196078431
R_L1_m_45_3 pixel_45 l1_msum_3 1000000
R_L1_m_46_3 pixel_46 l1_msum_3 1000000
R_L1_m_47_3 pixel_47 l1_msum_3 95890.410958904104
R_L1_m_48_3 pixel_48 l1_msum_3 1000000
R_L1_m_49_3 pixel_49 l1_msum_3 1000000
R_L1_m_50_3 pixel_50 l1_msum_3 1000000
R_L1_m_51_3 pixel_51 l1_msum_3 1000000
R_L1_m_52_3 pixel_52 l1_msum_3 1000000
R_L1_m_53_3 pixel_53 l1_msum_3 1000000
R_L1_m_54_3 pixel_54 l1_msum_3 1000000
R_L1_m_55_3 pixel_55 l1_msum_3 43478.260869565216
R_L1_m_56_3 pixel_56 l1_msum_3 1000000
R_L1_m_57_3 pixel_57 l1_msum_3 66037.735849056597
R_L1_m_58_3 pixel_58 l1_msum_3 1000000
R_L1_m_59_3 pixel_59 l1_msum_3 1000000
R_L1_m_60_3 pixel_60 l1_msum_3 1000000
R_L1_m_61_3 pixel_61 l1_msum_3 1000000
R_L1_m_62_3 pixel_62 l1_msum_3 1000000
R_L1_m_63_3 pixel_63 l1_msum_3 1000000
E_TIA_L1_m_3 l1_mout_3 0 0 l1_msum_3 100000000
R_FB_L1_m_3 l1_mout_3 l1_msum_3 1000
B_NEURON_L1_3 hidden_3 0 V={0.01*max(((V(l1_mout_3)-V(l1_pout_3))/0.0030903275574088963+(0.11970318108797073)),0)}
R_L1_p_0_4 pixel_0 l1_psum_4 241379.31034482759
R_L1_p_1_4 pixel_1 l1_psum_4 59829.059829059821
R_L1_p_2_4 pixel_2 l1_psum_4 83333.333333333328
R_L1_p_3_4 pixel_3 l1_psum_4 1000000
R_L1_p_4_4 pixel_4 l1_psum_4 1000000
R_L1_p_5_4 pixel_5 l1_psum_4 1000000
R_L1_p_6_4 pixel_6 l1_psum_4 388888.88888888888
R_L1_p_7_4 pixel_7 l1_psum_4 1000000
R_L1_p_8_4 pixel_8 l1_psum_4 50359.712230215831
R_L1_p_9_4 pixel_9 l1_psum_4 40697.674418604649
R_L1_p_10_4 pixel_10 l1_psum_4 83333.333333333328
R_L1_p_11_4 pixel_11 l1_psum_4 112903.22580645159
R_L1_p_12_4 pixel_12 l1_psum_4 112903.22580645159
R_L1_p_13_4 pixel_13 l1_psum_4 388888.88888888888
R_L1_p_14_4 pixel_14 l1_psum_4 83333.333333333328
R_L1_p_15_4 pixel_15 l1_psum_4 30837.004405286345
R_L1_p_16_4 pixel_16 l1_psum_4 241379.31034482759
R_L1_p_17_4 pixel_17 l1_psum_4 73684.210526315786
R_L1_p_18_4 pixel_18 l1_psum_4 50359.712230215831
R_L1_p_19_4 pixel_19 l1_psum_4 54687.499999999993
R_L1_p_20_4 pixel_20 l1_psum_4 32407.407407407409
R_L1_p_21_4 pixel_21 l1_psum_4 1000000
R_L1_p_22_4 pixel_22 l1_psum_4 1000000
R_L1_p_23_4 pixel_23 l1_psum_4 59829.059829059821
R_L1_p_24_4 pixel_24 l1_psum_4 112903.22580645159
R_L1_p_25_4 pixel_25 l1_psum_4 59829.059829059821
R_L1_p_26_4 pixel_26 l1_psum_4 95890.410958904104
R_L1_p_27_4 pixel_27 l1_psum_4 95890.410958904104
R_L1_p_28_4 pixel_28 l1_psum_4 1000000
R_L1_p_29_4 pixel_29 l1_psum_4 137254.90196078431
R_L1_p_30_4 pixel_30 l1_psum_4 1000000
R_L1_p_31_4 pixel_31 l1_psum_4 73684.210526315786
R_L1_p_32_4 pixel_32 l1_psum_4 112903.22580645159
R_L1_p_33_4 pixel_33 l1_psum_4 1000000
R_L1_p_34_4 pixel_34 l1_psum_4 1000000
R_L1_p_35_4 pixel_35 l1_psum_4 1000000
R_L1_p_36_4 pixel_36 l1_psum_4 1000000
R_L1_p_37_4 pixel_37 l1_psum_4 43478.260869565216
R_L1_p_38_4 pixel_38 l1_psum_4 38251.366120218576
R_L1_p_39_4 pixel_39 l1_psum_4 1000000
R_L1_p_40_4 pixel_40 l1_psum_4 29411.764705882353
R_L1_p_41_4 pixel_41 l1_psum_4 1000000
R_L1_p_42_4 pixel_42 l1_psum_4 1000000
R_L1_p_43_4 pixel_43 l1_psum_4 1000000
R_L1_p_44_4 pixel_44 l1_psum_4 112903.22580645159
R_L1_p_45_4 pixel_45 l1_psum_4 1000000
R_L1_p_46_4 pixel_46 l1_psum_4 388888.88888888888
R_L1_p_47_4 pixel_47 l1_psum_4 175000.00000000003
R_L1_p_48_4 pixel_48 l1_psum_4 83333.333333333328
R_L1_p_49_4 pixel_49 l1_psum_4 50359.712230215831
R_L1_p_50_4 pixel_50 l1_psum_4 38251.366120218576
R_L1_p_51_4 pixel_51 l1_psum_4 59829.059829059821
R_L1_p_52_4 pixel_52 l1_psum_4 95890.410958904104
R_L1_p_53_4 pixel_53 l1_psum_4 1000000
R_L1_p_54_4 pixel_54 l1_psum_4 1000000
R_L1_p_55_4 pixel_55 l1_psum_4 388888.88888888888
R_L1_p_56_4 pixel_56 l1_psum_4 66037.735849056597
R_L1_p_57_4 pixel_57 l1_psum_4 24822.695035460994
R_L1_p_58_4 pixel_58 l1_psum_4 32407.407407407409
R_L1_p_59_4 pixel_59 l1_psum_4 34146.341463414632
R_L1_p_60_4 pixel_60 l1_psum_4 26923.076923076922
R_L1_p_61_4 pixel_61 l1_psum_4 38251.366120218576
R_L1_p_62_4 pixel_62 l1_psum_4 24822.695035460994
R_L1_p_63_4 pixel_63 l1_psum_4 388888.88888888888
E_TIA_L1_p_4 l1_pout_4 0 0 l1_psum_4 100000000
R_FB_L1_p_4 l1_pout_4 l1_psum_4 1000
R_L1_m_0_4 pixel_0 l1_msum_4 1000000
R_L1_m_1_4 pixel_1 l1_msum_4 1000000
R_L1_m_2_4 pixel_2 l1_msum_4 1000000
R_L1_m_3_4 pixel_3 l1_msum_4 59829.059829059821
R_L1_m_4_4 pixel_4 l1_msum_4 66037.735849056597
R_L1_m_5_4 pixel_5 l1_msum_4 54687.499999999993
R_L1_m_6_4 pixel_6 l1_msum_4 1000000
R_L1_m_7_4 pixel_7 l1_msum_4 112903.22580645159
R_L1_m_8_4 pixel_8 l1_msum_4 1000000
R_L1_m_9_4 pixel_9 l1_msum_4 1000000
R_L1_m_10_4 pixel_10 l1_msum_4 1000000
R_L1_m_11_4 pixel_11 l1_msum_4 1000000
R_L1_m_12_4 pixel_12 l1_msum_4 1000000
R_L1_m_13_4 pixel_13 l1_msum_4 1000000
R_L1_m_14_4 pixel_14 l1_msum_4 1000000
R_L1_m_15_4 pixel_15 l1_msum_4 1000000
R_L1_m_16_4 pixel_16 l1_msum_4 1000000
R_L1_m_17_4 pixel_17 l1_msum_4 1000000
R_L1_m_18_4 pixel_18 l1_msum_4 1000000
R_L1_m_19_4 pixel_19 l1_msum_4 1000000
R_L1_m_20_4 pixel_20 l1_msum_4 1000000
R_L1_m_21_4 pixel_21 l1_msum_4 112903.22580645159
R_L1_m_22_4 pixel_22 l1_msum_4 46666.666666666664
R_L1_m_23_4 pixel_23 l1_msum_4 1000000
R_L1_m_24_4 pixel_24 l1_msum_4 1000000
R_L1_m_25_4 pixel_25 l1_msum_4 1000000
R_L1_m_26_4 pixel_26 l1_msum_4 1000000
R_L1_m_27_4 pixel_27 l1_msum_4 1000000
R_L1_m_28_4 pixel_28 l1_msum_4 137254.90196078431
R_L1_m_29_4 pixel_29 l1_msum_4 1000000
R_L1_m_30_4 pixel_30 l1_msum_4 83333.333333333328
R_L1_m_31_4 pixel_31 l1_msum_4 1000000
R_L1_m_32_4 pixel_32 l1_msum_4 1000000
R_L1_m_33_4 pixel_33 l1_msum_4 34146.341463414632
R_L1_m_34_4 pixel_34 l1_msum_4 29411.764705882353
R_L1_m_35_4 pixel_35 l1_msum_4 73684.210526315786
R_L1_m_36_4 pixel_36 l1_msum_4 73684.210526315786
R_L1_m_37_4 pixel_37 l1_msum_4 1000000
R_L1_m_38_4 pixel_38 l1_msum_4 1000000
R_L1_m_39_4 pixel_39 l1_msum_4 59829.059829059821
R_L1_m_40_4 pixel_40 l1_msum_4 1000000
R_L1_m_41_4 pixel_41 l1_msum_4 40697.674418604649
R_L1_m_42_4 pixel_42 l1_msum_4 23890.784982935158
R_L1_m_43_4 pixel_43 l1_msum_4 43478.260869565216
R_L1_m_44_4 pixel_44 l1_msum_4 1000000
R_L1_m_45_4 pixel_45 l1_msum_4 241379.31034482759
R_L1_m_46_4 pixel_46 l1_msum_4 1000000
R_L1_m_47_4 pixel_47 l1_msum_4 1000000
R_L1_m_48_4 pixel_48 l1_msum_4 1000000
R_L1_m_49_4 pixel_49 l1_msum_4 1000000
R_L1_m_50_4 pixel_50 l1_msum_4 1000000
R_L1_m_51_4 pixel_51 l1_msum_4 1000000
R_L1_m_52_4 pixel_52 l1_msum_4 1000000
R_L1_m_53_4 pixel_53 l1_msum_4 54687.499999999993
R_L1_m_54_4 pixel_54 l1_msum_4 388888.88888888888
R_L1_m_55_4 pixel_55 l1_msum_4 1000000
R_L1_m_56_4 pixel_56 l1_msum_4 1000000
R_L1_m_57_4 pixel_57 l1_msum_4 1000000
R_L1_m_58_4 pixel_58 l1_msum_4 1000000
R_L1_m_59_4 pixel_59 l1_msum_4 1000000
R_L1_m_60_4 pixel_60 l1_msum_4 1000000
R_L1_m_61_4 pixel_61 l1_msum_4 1000000
R_L1_m_62_4 pixel_62 l1_msum_4 1000000
R_L1_m_63_4 pixel_63 l1_msum_4 1000000
E_TIA_L1_m_4 l1_mout_4 0 0 l1_msum_4 100000000
R_FB_L1_m_4 l1_mout_4 l1_msum_4 1000
B_NEURON_L1_4 hidden_4 0 V={0.01*max(((V(l1_mout_4)-V(l1_pout_4))/0.0030903275574088963+(-0.08125169575214386)),0)}
R_L1_p_0_5 pixel_0 l1_psum_5 1000000
R_L1_p_1_5 pixel_1 l1_psum_5 241379.31034482759
R_L1_p_2_5 pixel_2 l1_psum_5 1000000
R_L1_p_3_5 pixel_3 l1_psum_5 1000000
R_L1_p_4_5 pixel_4 l1_psum_5 1000000
R_L1_p_5_5 pixel_5 l1_psum_5 1000000
R_L1_p_6_5 pixel_6 l1_psum_5 1000000
R_L1_p_7_5 pixel_7 l1_psum_5 1000000
R_L1_p_8_5 pixel_8 l1_psum_5 1000000
R_L1_p_9_5 pixel_9 l1_psum_5 95890.410958904104
R_L1_p_10_5 pixel_10 l1_psum_5 1000000
R_L1_p_11_5 pixel_11 l1_psum_5 137254.90196078431
R_L1_p_12_5 pixel_12 l1_psum_5 95890.410958904104
R_L1_p_13_5 pixel_13 l1_psum_5 1000000
R_L1_p_14_5 pixel_14 l1_psum_5 1000000
R_L1_p_15_5 pixel_15 l1_psum_5 1000000
R_L1_p_16_5 pixel_16 l1_psum_5 1000000
R_L1_p_17_5 pixel_17 l1_psum_5 59829.059829059821
R_L1_p_18_5 pixel_18 l1_psum_5 73684.210526315786
R_L1_p_19_5 pixel_19 l1_psum_5 175000.00000000003
R_L1_p_20_5 pixel_20 l1_psum_5 28112.449799196787
R_L1_p_21_5 pixel_21 l1_psum_5 175000.00000000003
R_L1_p_22_5 pixel_22 l1_psum_5 1000000
R_L1_p_23_5 pixel_23 l1_psum_5 1000000
R_L1_p_24_5 pixel_24 l1_psum_5 112903.22580645159
R_L1_p_25_5 pixel_25 l1_psum_5 1000000
R_L1_p_26_5 pixel_26 l1_psum_5 1000000
R_L1_p_27_5 pixel_27 l1_psum_5 1000000
R_L1_p_28_5 pixel_28 l1_psum_5 28112.449799196787
R_L1_p_29_5 pixel_29 l1_psum_5 38251.366120218576
R_L1_p_30_5 pixel_30 l1_psum_5 1000000
R_L1_p_31_5 pixel_31 l1_psum_5 1000000
R_L1_p_32_5 pixel_32 l1_psum_5 1000000
R_L1_p_33_5 pixel_33 l1_psum_5 1000000
R_L1_p_34_5 pixel_34 l1_psum_5 1000000
R_L1_p_35_5 pixel_35 l1_psum_5 50359.712230215831
R_L1_p_36_5 pixel_36 l1_psum_5 83333.333333333328
R_L1_p_37_5 pixel_37 l1_psum_5 1000000
R_L1_p_38_5 pixel_38 l1_psum_5 1000000
R_L1_p_39_5 pixel_39 l1_psum_5 1000000
R_L1_p_40_5 pixel_40 l1_psum_5 1000000
R_L1_p_41_5 pixel_41 l1_psum_5 1000000
R_L1_p_42_5 pixel_42 l1_psum_5 1000000
R_L1_p_43_5 pixel_43 l1_psum_5 59829.059829059821
R_L1_p_44_5 pixel_44 l1_psum_5 1000000
R_L1_p_45_5 pixel_45 l1_psum_5 1000000
R_L1_p_46_5 pixel_46 l1_psum_5 1000000
R_L1_p_47_5 pixel_47 l1_psum_5 388888.88888888888
R_L1_p_48_5 pixel_48 l1_psum_5 1000000
R_L1_p_49_5 pixel_49 l1_psum_5 1000000
R_L1_p_50_5 pixel_50 l1_psum_5 1000000
R_L1_p_51_5 pixel_51 l1_psum_5 1000000
R_L1_p_52_5 pixel_52 l1_psum_5 1000000
R_L1_p_53_5 pixel_53 l1_psum_5 137254.90196078431
R_L1_p_54_5 pixel_54 l1_psum_5 1000000
R_L1_p_55_5 pixel_55 l1_psum_5 40697.674418604649
R_L1_p_56_5 pixel_56 l1_psum_5 1000000
R_L1_p_57_5 pixel_57 l1_psum_5 36082.474226804123
R_L1_p_58_5 pixel_58 l1_psum_5 1000000
R_L1_p_59_5 pixel_59 l1_psum_5 1000000
R_L1_p_60_5 pixel_60 l1_psum_5 83333.333333333328
R_L1_p_61_5 pixel_61 l1_psum_5 175000.00000000003
R_L1_p_62_5 pixel_62 l1_psum_5 175000.00000000003
R_L1_p_63_5 pixel_63 l1_psum_5 112903.22580645159
E_TIA_L1_p_5 l1_pout_5 0 0 l1_psum_5 100000000
R_FB_L1_p_5 l1_pout_5 l1_psum_5 1000
R_L1_m_0_5 pixel_0 l1_msum_5 95890.410958904104
R_L1_m_1_5 pixel_1 l1_msum_5 1000000
R_L1_m_2_5 pixel_2 l1_msum_5 21472.39263803681
R_L1_m_3_5 pixel_3 l1_msum_5 1000000
R_L1_m_4_5 pixel_4 l1_msum_5 40697.674418604649
R_L1_m_5_5 pixel_5 l1_msum_5 18372.70341207349
R_L1_m_6_5 pixel_6 l1_msum_5 34146.341463414632
R_L1_m_7_5 pixel_7 l1_msum_5 66037.735849056597
R_L1_m_8_5 pixel_8 l1_msum_5 241379.31034482759
R_L1_m_9_5 pixel_9 l1_msum_5 1000000
R_L1_m_10_5 pixel_10 l1_msum_5 175000.00000000003
R_L1_m_11_5 pixel_11 l1_msum_5 1000000
R_L1_m_12_5 pixel_12 l1_msum_5 1000000
R_L1_m_13_5 pixel_13 l1_msum_5 40697.674418604649
R_L1_m_14_5 pixel_14 l1_msum_5 43478.260869565216
R_L1_m_15_5 pixel_15 l1_msum_5 137254.90196078431
R_L1_m_16_5 pixel_16 l1_msum_5 54687.499999999993
R_L1_m_17_5 pixel_17 l1_msum_5 1000000
R_L1_m_18_5 pixel_18 l1_msum_5 1000000
R_L1_m_19_5 pixel_19 l1_msum_5 1000000
R_L1_m_20_5 pixel_20 l1_msum_5 1000000
R_L1_m_21_5 pixel_21 l1_msum_5 1000000
R_L1_m_22_5 pixel_22 l1_msum_5 18372.70341207349
R_L1_m_23_5 pixel_23 l1_msum_5 59829.059829059821
R_L1_m_24_5 pixel_24 l1_msum_5 1000000
R_L1_m_25_5 pixel_25 l1_msum_5 388888.88888888888
R_L1_m_26_5 pixel_26 l1_msum_5 175000.00000000003
R_L1_m_27_5 pixel_27 l1_msum_5 66037.735849056597
R_L1_m_28_5 pixel_28 l1_msum_5 1000000
R_L1_m_29_5 pixel_29 l1_msum_5 1000000
R_L1_m_30_5 pixel_30 l1_msum_5 15659.955257270693
R_L1_m_31_5 pixel_31 l1_msum_5 16470.588235294119
R_L1_m_32_5 pixel_32 l1_msum_5 54687.499999999993
R_L1_m_33_5 pixel_33 l1_msum_5 15659.955257270693
R_L1_m_34_5 pixel_34 l1_msum_5 66037.735849056597
R_L1_m_35_5 pixel_35 l1_msum_5 1000000
R_L1_m_36_5 pixel_36 l1_msum_5 1000000
R_L1_m_37_5 pixel_37 l1_msum_5 54687.499999999993
R_L1_m_38_5 pixel_38 l1_msum_5 18372.70341207349
R_L1_m_39_5 pixel_39 l1_msum_5 83333.333333333328
R_L1_m_40_5 pixel_40 l1_msum_5 95890.410958904104
R_L1_m_41_5 pixel_41 l1_msum_5 15659.955257270693
R_L1_m_42_5 pixel_42 l1_msum_5 241379.31034482759
R_L1_m_43_5 pixel_43 l1_msum_5 1000000
R_L1_m_44_5 pixel_44 l1_msum_5 388888.88888888888
R_L1_m_45_5 pixel_45 l1_msum_5 50359.712230215831
R_L1_m_46_5 pixel_46 l1_msum_5 66037.735849056597
R_L1_m_47_5 pixel_47 l1_msum_5 1000000
R_L1_m_48_5 pixel_48 l1_msum_5 32407.407407407409
R_L1_m_49_5 pixel_49 l1_msum_5 43478.260869565216
R_L1_m_50_5 pixel_50 l1_msum_5 112903.22580645159
R_L1_m_51_5 pixel_51 l1_msum_5 137254.90196078431
R_L1_m_52_5 pixel_52 l1_msum_5 388888.88888888888
R_L1_m_53_5 pixel_53 l1_msum_5 1000000
R_L1_m_54_5 pixel_54 l1_msum_5 112903.22580645159
R_L1_m_55_5 pixel_55 l1_msum_5 1000000
R_L1_m_56_5 pixel_56 l1_msum_5 241379.31034482759
R_L1_m_57_5 pixel_57 l1_msum_5 1000000
R_L1_m_58_5 pixel_58 l1_msum_5 1000000
R_L1_m_59_5 pixel_59 l1_msum_5 241379.31034482759
R_L1_m_60_5 pixel_60 l1_msum_5 1000000
R_L1_m_61_5 pixel_61 l1_msum_5 1000000
R_L1_m_62_5 pixel_62 l1_msum_5 1000000
R_L1_m_63_5 pixel_63 l1_msum_5 1000000
E_TIA_L1_m_5 l1_mout_5 0 0 l1_msum_5 100000000
R_FB_L1_m_5 l1_mout_5 l1_msum_5 1000
B_NEURON_L1_5 hidden_5 0 V={0.01*max(((V(l1_mout_5)-V(l1_pout_5))/0.0030903275574088963+(0.11298089474439621)),0)}
R_L1_p_0_6 pixel_0 l1_psum_6 1000000
R_L1_p_1_6 pixel_1 l1_psum_6 1000000
R_L1_p_2_6 pixel_2 l1_psum_6 1000000
R_L1_p_3_6 pixel_3 l1_psum_6 1000000
R_L1_p_4_6 pixel_4 l1_psum_6 1000000
R_L1_p_5_6 pixel_5 l1_psum_6 1000000
R_L1_p_6_6 pixel_6 l1_psum_6 1000000
R_L1_p_7_6 pixel_7 l1_psum_6 59829.059829059821
R_L1_p_8_6 pixel_8 l1_psum_6 1000000
R_L1_p_9_6 pixel_9 l1_psum_6 1000000
R_L1_p_10_6 pixel_10 l1_psum_6 1000000
R_L1_p_11_6 pixel_11 l1_psum_6 1000000
R_L1_p_12_6 pixel_12 l1_psum_6 1000000
R_L1_p_13_6 pixel_13 l1_psum_6 1000000
R_L1_p_14_6 pixel_14 l1_psum_6 1000000
R_L1_p_15_6 pixel_15 l1_psum_6 1000000
R_L1_p_16_6 pixel_16 l1_psum_6 1000000
R_L1_p_17_6 pixel_17 l1_psum_6 1000000
R_L1_p_18_6 pixel_18 l1_psum_6 1000000
R_L1_p_19_6 pixel_19 l1_psum_6 175000.00000000003
R_L1_p_20_6 pixel_20 l1_psum_6 30837.004405286345
R_L1_p_21_6 pixel_21 l1_psum_6 83333.333333333328
R_L1_p_22_6 pixel_22 l1_psum_6 50359.712230215831
R_L1_p_23_6 pixel_23 l1_psum_6 38251.366120218576
R_L1_p_24_6 pixel_24 l1_psum_6 1000000
R_L1_p_25_6 pixel_25 l1_psum_6 1000000
R_L1_p_26_6 pixel_26 l1_psum_6 73684.210526315786
R_L1_p_27_6 pixel_27 l1_psum_6 112903.22580645159
R_L1_p_28_6 pixel_28 l1_psum_6 241379.31034482759
R_L1_p_29_6 pixel_29 l1_psum_6 1000000
R_L1_p_30_6 pixel_30 l1_psum_6 1000000
R_L1_p_31_6 pixel_31 l1_psum_6 23026.315789473687
R_L1_p_32_6 pixel_32 l1_psum_6 1000000
R_L1_p_33_6 pixel_33 l1_psum_6 175000.00000000003
R_L1_p_34_6 pixel_34 l1_psum_6 36082.474226804123
R_L1_p_35_6 pixel_35 l1_psum_6 1000000
R_L1_p_36_6 pixel_36 l1_psum_6 83333.333333333328
R_L1_p_37_6 pixel_37 l1_psum_6 1000000
R_L1_p_38_6 pixel_38 l1_psum_6 1000000
R_L1_p_39_6 pixel_39 l1_psum_6 1000000
R_L1_p_40_6 pixel_40 l1_psum_6 1000000
R_L1_p_41_6 pixel_41 l1_psum_6 1000000
R_L1_p_42_6 pixel_42 l1_psum_6 1000000
R_L1_p_43_6 pixel_43 l1_psum_6 66037.735849056597
R_L1_p_44_6 pixel_44 l1_psum_6 1000000
R_L1_p_45_6 pixel_45 l1_psum_6 1000000
R_L1_p_46_6 pixel_46 l1_psum_6 95890.410958904104
R_L1_p_47_6 pixel_47 l1_psum_6 32407.407407407409
R_L1_p_48_6 pixel_48 l1_psum_6 1000000
R_L1_p_49_6 pixel_49 l1_psum_6 1000000
R_L1_p_50_6 pixel_50 l1_psum_6 1000000
R_L1_p_51_6 pixel_51 l1_psum_6 1000000
R_L1_p_52_6 pixel_52 l1_psum_6 1000000
R_L1_p_53_6 pixel_53 l1_psum_6 1000000
R_L1_p_54_6 pixel_54 l1_psum_6 1000000
R_L1_p_55_6 pixel_55 l1_psum_6 50359.712230215831
R_L1_p_56_6 pixel_56 l1_psum_6 30837.004405286345
R_L1_p_57_6 pixel_57 l1_psum_6 175000.00000000003
R_L1_p_58_6 pixel_58 l1_psum_6 1000000
R_L1_p_59_6 pixel_59 l1_psum_6 1000000
R_L1_p_60_6 pixel_60 l1_psum_6 241379.31034482759
R_L1_p_61_6 pixel_61 l1_psum_6 1000000
R_L1_p_62_6 pixel_62 l1_psum_6 29411.764705882353
R_L1_p_63_6 pixel_63 l1_psum_6 1000000
E_TIA_L1_p_6 l1_pout_6 0 0 l1_psum_6 100000000
R_FB_L1_p_6 l1_pout_6 l1_psum_6 1000
R_L1_m_0_6 pixel_0 l1_msum_6 59829.059829059821
R_L1_m_1_6 pixel_1 l1_msum_6 1000000
R_L1_m_2_6 pixel_2 l1_msum_6 83333.333333333328
R_L1_m_3_6 pixel_3 l1_msum_6 43478.260869565216
R_L1_m_4_6 pixel_4 l1_msum_6 19498.607242339833
R_L1_m_5_6 pixel_5 l1_msum_6 13645.22417153996
R_L1_m_6_6 pixel_6 l1_msum_6 14256.619144602852
R_L1_m_7_6 pixel_7 l1_msum_6 1000000
R_L1_m_8_6 pixel_8 l1_msum_6 38251.366120218576
R_L1_m_9_6 pixel_9 l1_msum_6 38251.366120218576
R_L1_m_10_6 pixel_10 l1_msum_6 38251.366120218576
R_L1_m_11_6 pixel_11 l1_msum_6 241379.31034482759
R_L1_m_12_6 pixel_12 l1_msum_6 34146.341463414632
R_L1_m_13_6 pixel_13 l1_msum_6 36082.474226804123
R_L1_m_14_6 pixel_14 l1_msum_6 38251.366120218576
R_L1_m_15_6 pixel_15 l1_msum_6 30837.004405286345
R_L1_m_16_6 pixel_16 l1_msum_6 32407.407407407409
R_L1_m_17_6 pixel_17 l1_msum_6 29411.764705882353
R_L1_m_18_6 pixel_18 l1_msum_6 36082.474226804123
R_L1_m_19_6 pixel_19 l1_msum_6 1000000
R_L1_m_20_6 pixel_20 l1_msum_6 1000000
R_L1_m_21_6 pixel_21 l1_msum_6 1000000
R_L1_m_22_6 pixel_22 l1_msum_6 1000000
R_L1_m_23_6 pixel_23 l1_msum_6 1000000
R_L1_m_24_6 pixel_24 l1_msum_6 73684.210526315786
R_L1_m_25_6 pixel_25 l1_msum_6 73684.210526315786
R_L1_m_26_6 pixel_26 l1_msum_6 1000000
R_L1_m_27_6 pixel_27 l1_msum_6 1000000
R_L1_m_28_6 pixel_28 l1_msum_6 1000000
R_L1_m_29_6 pixel_29 l1_msum_6 83333.333333333328
R_L1_m_30_6 pixel_30 l1_msum_6 73684.210526315786
R_L1_m_31_6 pixel_31 l1_msum_6 1000000
R_L1_m_32_6 pixel_32 l1_msum_6 16908.212560386473
R_L1_m_33_6 pixel_33 l1_msum_6 1000000
R_L1_m_34_6 pixel_34 l1_msum_6 1000000
R_L1_m_35_6 pixel_35 l1_msum_6 1000000
R_L1_m_36_6 pixel_36 l1_msum_6 1000000
R_L1_m_37_6 pixel_37 l1_msum_6 38251.366120218576
R_L1_m_38_6 pixel_38 l1_msum_6 83333.333333333328
R_L1_m_39_6 pixel_39 l1_msum_6 388888.88888888888
R_L1_m_40_6 pixel_40 l1_msum_6 22222.222222222223
R_L1_m_41_6 pixel_41 l1_msum_6 1000000
R_L1_m_42_6 pixel_42 l1_msum_6 1000000
R_L1_m_43_6 pixel_43 l1_msum_6 1000000
R_L1_m_44_6 pixel_44 l1_msum_6 43478.260869565216
R_L1_m_45_6 pixel_45 l1_msum_6 241379.31034482759
R_L1_m_46_6 pixel_46 l1_msum_6 1000000
R_L1_m_47_6 pixel_47 l1_msum_6 1000000
R_L1_m_48_6 pixel_48 l1_msum_6 95890.410958904104
R_L1_m_49_6 pixel_49 l1_msum_6 43478.260869565216
R_L1_m_50_6 pixel_50 l1_msum_6 83333.333333333328
R_L1_m_51_6 pixel_51 l1_msum_6 59829.059829059821
R_L1_m_52_6 pixel_52 l1_msum_6 23026.315789473687
R_L1_m_53_6 pixel_53 l1_msum_6 73684.210526315786
R_L1_m_54_6 pixel_54 l1_msum_6 1000000
R_L1_m_55_6 pixel_55 l1_msum_6 1000000
R_L1_m_56_6 pixel_56 l1_msum_6 1000000
R_L1_m_57_6 pixel_57 l1_msum_6 1000000
R_L1_m_58_6 pixel_58 l1_msum_6 95890.410958904104
R_L1_m_59_6 pixel_59 l1_msum_6 1000000
R_L1_m_60_6 pixel_60 l1_msum_6 1000000
R_L1_m_61_6 pixel_61 l1_msum_6 1000000
R_L1_m_62_6 pixel_62 l1_msum_6 1000000
R_L1_m_63_6 pixel_63 l1_msum_6 241379.31034482759
E_TIA_L1_m_6 l1_mout_6 0 0 l1_msum_6 100000000
R_FB_L1_m_6 l1_mout_6 l1_msum_6 1000
B_NEURON_L1_6 hidden_6 0 V={0.01*max(((V(l1_mout_6)-V(l1_pout_6))/0.0030903275574088963+(0.70083451271057129)),0)}
R_L1_p_0_7 pixel_0 l1_psum_7 46666.666666666664
R_L1_p_1_7 pixel_1 l1_psum_7 21472.39263803681
R_L1_p_2_7 pixel_2 l1_psum_7 14256.619144602852
R_L1_p_3_7 pixel_3 l1_psum_7 19498.607242339833
R_L1_p_4_7 pixel_4 l1_psum_7 34146.341463414632
R_L1_p_5_7 pixel_5 l1_psum_7 34146.341463414632
R_L1_p_6_7 pixel_6 l1_psum_7 54687.499999999993
R_L1_p_7_7 pixel_7 l1_psum_7 95890.410958904104
R_L1_p_8_7 pixel_8 l1_psum_7 1000000
R_L1_p_9_7 pixel_9 l1_psum_7 241379.31034482759
R_L1_p_10_7 pixel_10 l1_psum_7 1000000
R_L1_p_11_7 pixel_11 l1_psum_7 1000000
R_L1_p_12_7 pixel_12 l1_psum_7 241379.31034482759
R_L1_p_13_7 pixel_13 l1_psum_7 388888.88888888888
R_L1_p_14_7 pixel_14 l1_psum_7 1000000
R_L1_p_15_7 pixel_15 l1_psum_7 112903.22580645159
R_L1_p_16_7 pixel_16 l1_psum_7 1000000
R_L1_p_17_7 pixel_17 l1_psum_7 112903.22580645159
R_L1_p_18_7 pixel_18 l1_psum_7 388888.88888888888
R_L1_p_19_7 pixel_19 l1_psum_7 1000000
R_L1_p_20_7 pixel_20 l1_psum_7 95890.410958904104
R_L1_p_21_7 pixel_21 l1_psum_7 1000000
R_L1_p_22_7 pixel_22 l1_psum_7 1000000
R_L1_p_23_7 pixel_23 l1_psum_7 73684.210526315786
R_L1_p_24_7 pixel_24 l1_psum_7 1000000
R_L1_p_25_7 pixel_25 l1_psum_7 175000.00000000003
R_L1_p_26_7 pixel_26 l1_psum_7 1000000
R_L1_p_27_7 pixel_27 l1_psum_7 112903.22580645159
R_L1_p_28_7 pixel_28 l1_psum_7 388888.88888888888
R_L1_p_29_7 pixel_29 l1_psum_7 241379.31034482759
R_L1_p_30_7 pixel_30 l1_psum_7 59829.059829059821
R_L1_p_31_7 pixel_31 l1_psum_7 34146.341463414632
R_L1_p_32_7 pixel_32 l1_psum_7 241379.31034482759
R_L1_p_33_7 pixel_33 l1_psum_7 1000000
R_L1_p_34_7 pixel_34 l1_psum_7 112903.22580645159
R_L1_p_35_7 pixel_35 l1_psum_7 26923.076923076922
R_L1_p_36_7 pixel_36 l1_psum_7 1000000
R_L1_p_37_7 pixel_37 l1_psum_7 95890.410958904104
R_L1_p_38_7 pixel_38 l1_psum_7 175000.00000000003
R_L1_p_39_7 pixel_39 l1_psum_7 20771.51335311573
R_L1_p_40_7 pixel_40 l1_psum_7 59829.059829059821
R_L1_p_41_7 pixel_41 l1_psum_7 83333.333333333328
R_L1_p_42_7 pixel_42 l1_psum_7 95890.410958904104
R_L1_p_43_7 pixel_43 l1_psum_7 73684.210526315786
R_L1_p_44_7 pixel_44 l1_psum_7 40697.674418604649
R_L1_p_45_7 pixel_45 l1_psum_7 1000000
R_L1_p_46_7 pixel_46 l1_psum_7 1000000
R_L1_p_47_7 pixel_47 l1_psum_7 388888.88888888888
R_L1_p_48_7 pixel_48 l1_psum_7 23026.315789473687
R_L1_p_49_7 pixel_49 l1_psum_7 1000000
R_L1_p_50_7 pixel_50 l1_psum_7 73684.210526315786
R_L1_p_51_7 pixel_51 l1_psum_7 32407.407407407409
R_L1_p_52_7 pixel_52 l1_psum_7 66037.735849056597
R_L1_p_53_7 pixel_53 l1_psum_7 1000000
R_L1_p_54_7 pixel_54 l1_psum_7 1000000
R_L1_p_55_7 pixel_55 l1_psum_7 112903.22580645159
R_L1_p_56_7 pixel_56 l1_psum_7 1000000
R_L1_p_57_7 pixel_57 l1_psum_7 1000000
R_L1_p_58_7 pixel_58 l1_psum_7 1000000
R_L1_p_59_7 pixel_59 l1_psum_7 175000.00000000003
R_L1_p_60_7 pixel_60 l1_psum_7 137254.90196078431
R_L1_p_61_7 pixel_61 l1_psum_7 112903.22580645159
R_L1_p_62_7 pixel_62 l1_psum_7 1000000
R_L1_p_63_7 pixel_63 l1_psum_7 175000.00000000003
E_TIA_L1_p_7 l1_pout_7 0 0 l1_psum_7 100000000
R_FB_L1_p_7 l1_pout_7 l1_psum_7 1000
R_L1_m_0_7 pixel_0 l1_msum_7 1000000
R_L1_m_1_7 pixel_1 l1_msum_7 1000000
R_L1_m_2_7 pixel_2 l1_msum_7 1000000
R_L1_m_3_7 pixel_3 l1_msum_7 1000000
R_L1_m_4_7 pixel_4 l1_msum_7 1000000
R_L1_m_5_7 pixel_5 l1_msum_7 1000000
R_L1_m_6_7 pixel_6 l1_msum_7 1000000
R_L1_m_7_7 pixel_7 l1_msum_7 1000000
R_L1_m_8_7 pixel_8 l1_msum_7 95890.410958904104
R_L1_m_9_7 pixel_9 l1_msum_7 1000000
R_L1_m_10_7 pixel_10 l1_msum_7 137254.90196078431
R_L1_m_11_7 pixel_11 l1_msum_7 112903.22580645159
R_L1_m_12_7 pixel_12 l1_msum_7 1000000
R_L1_m_13_7 pixel_13 l1_msum_7 1000000
R_L1_m_14_7 pixel_14 l1_msum_7 66037.735849056597
R_L1_m_15_7 pixel_15 l1_msum_7 1000000
R_L1_m_16_7 pixel_16 l1_msum_7 112903.22580645159
R_L1_m_17_7 pixel_17 l1_msum_7 1000000
R_L1_m_18_7 pixel_18 l1_msum_7 1000000
R_L1_m_19_7 pixel_19 l1_msum_7 73684.210526315786
R_L1_m_20_7 pixel_20 l1_msum_7 1000000
R_L1_m_21_7 pixel_21 l1_msum_7 112903.22580645159
R_L1_m_22_7 pixel_22 l1_msum_7 1000000
R_L1_m_23_7 pixel_23 l1_msum_7 1000000
R_L1_m_24_7 pixel_24 l1_msum_7 40697.674418604649
R_L1_m_25_7 pixel_25 l1_msum_7 1000000
R_L1_m_26_7 pixel_26 l1_msum_7 83333.333333333328
R_L1_m_27_7 pixel_27 l1_msum_7 1000000
R_L1_m_28_7 pixel_28 l1_msum_7 1000000
R_L1_m_29_7 pixel_29 l1_msum_7 1000000
R_L1_m_30_7 pixel_30 l1_msum_7 1000000
R_L1_m_31_7 pixel_31 l1_msum_7 1000000
R_L1_m_32_7 pixel_32 l1_msum_7 1000000
R_L1_m_33_7 pixel_33 l1_msum_7 95890.410958904104
R_L1_m_34_7 pixel_34 l1_msum_7 1000000
R_L1_m_35_7 pixel_35 l1_msum_7 1000000
R_L1_m_36_7 pixel_36 l1_msum_7 59829.059829059821
R_L1_m_37_7 pixel_37 l1_msum_7 1000000
R_L1_m_38_7 pixel_38 l1_msum_7 1000000
R_L1_m_39_7 pixel_39 l1_msum_7 1000000
R_L1_m_40_7 pixel_40 l1_msum_7 1000000
R_L1_m_41_7 pixel_41 l1_msum_7 1000000
R_L1_m_42_7 pixel_42 l1_msum_7 1000000
R_L1_m_43_7 pixel_43 l1_msum_7 1000000
R_L1_m_44_7 pixel_44 l1_msum_7 1000000
R_L1_m_45_7 pixel_45 l1_msum_7 241379.31034482759
R_L1_m_46_7 pixel_46 l1_msum_7 1000000
R_L1_m_47_7 pixel_47 l1_msum_7 1000000
R_L1_m_48_7 pixel_48 l1_msum_7 1000000
R_L1_m_49_7 pixel_49 l1_msum_7 137254.90196078431
R_L1_m_50_7 pixel_50 l1_msum_7 1000000
R_L1_m_51_7 pixel_51 l1_msum_7 1000000
R_L1_m_52_7 pixel_52 l1_msum_7 1000000
R_L1_m_53_7 pixel_53 l1_msum_7 241379.31034482759
R_L1_m_54_7 pixel_54 l1_msum_7 241379.31034482759
R_L1_m_55_7 pixel_55 l1_msum_7 1000000
R_L1_m_56_7 pixel_56 l1_msum_7 46666.666666666664
R_L1_m_57_7 pixel_57 l1_msum_7 1000000
R_L1_m_58_7 pixel_58 l1_msum_7 1000000
R_L1_m_59_7 pixel_59 l1_msum_7 1000000
R_L1_m_60_7 pixel_60 l1_msum_7 1000000
R_L1_m_61_7 pixel_61 l1_msum_7 1000000
R_L1_m_62_7 pixel_62 l1_msum_7 59829.059829059821
R_L1_m_63_7 pixel_63 l1_msum_7 1000000
E_TIA_L1_m_7 l1_mout_7 0 0 l1_msum_7 100000000
R_FB_L1_m_7 l1_mout_7 l1_msum_7 1000
B_NEURON_L1_7 hidden_7 0 V={0.01*max(((V(l1_mout_7)-V(l1_pout_7))/0.0030903275574088963+(-0.01232470665127039)),0)}
R_L1_p_0_8 pixel_0 l1_psum_8 66037.735849056597
R_L1_p_1_8 pixel_1 l1_psum_8 1000000
R_L1_p_2_8 pixel_2 l1_psum_8 1000000
R_L1_p_3_8 pixel_3 l1_psum_8 241379.31034482759
R_L1_p_4_8 pixel_4 l1_psum_8 137254.90196078431
R_L1_p_5_8 pixel_5 l1_psum_8 1000000
R_L1_p_6_8 pixel_6 l1_psum_8 241379.31034482759
R_L1_p_7_8 pixel_7 l1_psum_8 175000.00000000003
R_L1_p_8_8 pixel_8 l1_psum_8 46666.666666666664
R_L1_p_9_8 pixel_9 l1_psum_8 1000000
R_L1_p_10_8 pixel_10 l1_psum_8 112903.22580645159
R_L1_p_11_8 pixel_11 l1_psum_8 95890.410958904104
R_L1_p_12_8 pixel_12 l1_psum_8 1000000
R_L1_p_13_8 pixel_13 l1_psum_8 1000000
R_L1_p_14_8 pixel_14 l1_psum_8 175000.00000000003
R_L1_p_15_8 pixel_15 l1_psum_8 137254.90196078431
R_L1_p_16_8 pixel_16 l1_psum_8 73684.210526315786
R_L1_p_17_8 pixel_17 l1_psum_8 1000000
R_L1_p_18_8 pixel_18 l1_psum_8 112903.22580645159
R_L1_p_19_8 pixel_19 l1_psum_8 1000000
R_L1_p_20_8 pixel_20 l1_psum_8 1000000
R_L1_p_21_8 pixel_21 l1_psum_8 175000.00000000003
R_L1_p_22_8 pixel_22 l1_psum_8 59829.059829059821
R_L1_p_23_8 pixel_23 l1_psum_8 29411.764705882353
R_L1_p_24_8 pixel_24 l1_psum_8 1000000
R_L1_p_25_8 pixel_25 l1_psum_8 1000000
R_L1_p_26_8 pixel_26 l1_psum_8 1000000
R_L1_p_27_8 pixel_27 l1_psum_8 43478.260869565216
R_L1_p_28_8 pixel_28 l1_psum_8 1000000
R_L1_p_29_8 pixel_29 l1_psum_8 1000000
R_L1_p_30_8 pixel_30 l1_psum_8 95890.410958904104
R_L1_p_31_8 pixel_31 l1_psum_8 95890.410958904104
R_L1_p_32_8 pixel_32 l1_psum_8 1000000
R_L1_p_33_8 pixel_33 l1_psum_8 1000000
R_L1_p_34_8 pixel_34 l1_psum_8 43478.260869565216
R_L1_p_35_8 pixel_35 l1_psum_8 73684.210526315786
R_L1_p_36_8 pixel_36 l1_psum_8 1000000
R_L1_p_37_8 pixel_37 l1_psum_8 73684.210526315786
R_L1_p_38_8 pixel_38 l1_psum_8 95890.410958904104
R_L1_p_39_8 pixel_39 l1_psum_8 1000000
R_L1_p_40_8 pixel_40 l1_psum_8 95890.410958904104
R_L1_p_41_8 pixel_41 l1_psum_8 59829.059829059821
R_L1_p_42_8 pixel_42 l1_psum_8 59829.059829059821
R_L1_p_43_8 pixel_43 l1_psum_8 95890.410958904104
R_L1_p_44_8 pixel_44 l1_psum_8 1000000
R_L1_p_45_8 pixel_45 l1_psum_8 1000000
R_L1_p_46_8 pixel_46 l1_psum_8 137254.90196078431
R_L1_p_47_8 pixel_47 l1_psum_8 1000000
R_L1_p_48_8 pixel_48 l1_psum_8 43478.260869565216
R_L1_p_49_8 pixel_49 l1_psum_8 175000.00000000003
R_L1_p_50_8 pixel_50 l1_psum_8 137254.90196078431
R_L1_p_51_8 pixel_51 l1_psum_8 50359.712230215831
R_L1_p_52_8 pixel_52 l1_psum_8 175000.00000000003
R_L1_p_53_8 pixel_53 l1_psum_8 1000000
R_L1_p_54_8 pixel_54 l1_psum_8 1000000
R_L1_p_55_8 pixel_55 l1_psum_8 1000000
R_L1_p_56_8 pixel_56 l1_psum_8 1000000
R_L1_p_57_8 pixel_57 l1_psum_8 1000000
R_L1_p_58_8 pixel_58 l1_psum_8 1000000
R_L1_p_59_8 pixel_59 l1_psum_8 1000000
R_L1_p_60_8 pixel_60 l1_psum_8 1000000
R_L1_p_61_8 pixel_61 l1_psum_8 1000000
R_L1_p_62_8 pixel_62 l1_psum_8 1000000
R_L1_p_63_8 pixel_63 l1_psum_8 388888.88888888888
E_TIA_L1_p_8 l1_pout_8 0 0 l1_psum_8 100000000
R_FB_L1_p_8 l1_pout_8 l1_psum_8 1000
R_L1_m_0_8 pixel_0 l1_msum_8 1000000
R_L1_m_1_8 pixel_1 l1_msum_8 34146.341463414632
R_L1_m_2_8 pixel_2 l1_msum_8 388888.88888888888
R_L1_m_3_8 pixel_3 l1_msum_8 1000000
R_L1_m_4_8 pixel_4 l1_msum_8 1000000
R_L1_m_5_8 pixel_5 l1_msum_8 388888.88888888888
R_L1_m_6_8 pixel_6 l1_msum_8 1000000
R_L1_m_7_8 pixel_7 l1_msum_8 1000000
R_L1_m_8_8 pixel_8 l1_msum_8 1000000
R_L1_m_9_8 pixel_9 l1_msum_8 112903.22580645159
R_L1_m_10_8 pixel_10 l1_msum_8 1000000
R_L1_m_11_8 pixel_11 l1_msum_8 1000000
R_L1_m_12_8 pixel_12 l1_msum_8 175000.00000000003
R_L1_m_13_8 pixel_13 l1_msum_8 43478.260869565216
R_L1_m_14_8 pixel_14 l1_msum_8 1000000
R_L1_m_15_8 pixel_15 l1_msum_8 1000000
R_L1_m_16_8 pixel_16 l1_msum_8 1000000
R_L1_m_17_8 pixel_17 l1_msum_8 1000000
R_L1_m_18_8 pixel_18 l1_msum_8 1000000
R_L1_m_19_8 pixel_19 l1_msum_8 1000000
R_L1_m_20_8 pixel_20 l1_msum_8 241379.31034482759
R_L1_m_21_8 pixel_21 l1_msum_8 1000000
R_L1_m_22_8 pixel_22 l1_msum_8 1000000
R_L1_m_23_8 pixel_23 l1_msum_8 1000000
R_L1_m_24_8 pixel_24 l1_msum_8 137254.90196078431
R_L1_m_25_8 pixel_25 l1_msum_8 95890.410958904104
R_L1_m_26_8 pixel_26 l1_msum_8 59829.059829059821
R_L1_m_27_8 pixel_27 l1_msum_8 1000000
R_L1_m_28_8 pixel_28 l1_msum_8 112903.22580645159
R_L1_m_29_8 pixel_29 l1_msum_8 175000.00000000003
R_L1_m_30_8 pixel_30 l1_msum_8 1000000
R_L1_m_31_8 pixel_31 l1_msum_8 1000000
R_L1_m_32_8 pixel_32 l1_msum_8 112903.22580645159
R_L1_m_33_8 pixel_33 l1_msum_8 1000000
R_L1_m_34_8 pixel_34 l1_msum_8 1000000
R_L1_m_35_8 pixel_35 l1_msum_8 1000000
R_L1_m_36_8 pixel_36 l1_msum_8 137254.90196078431
R_L1_m_37_8 pixel_37 l1_msum_8 1000000
R_L1_m_38_8 pixel_38 l1_msum_8 1000000
R_L1_m_39_8 pixel_39 l1_msum_8 112903.22580645159
R_L1_m_40_8 pixel_40 l1_msum_8 1000000
R_L1_m_41_8 pixel_41 l1_msum_8 1000000
R_L1_m_42_8 pixel_42 l1_msum_8 1000000
R_L1_m_43_8 pixel_43 l1_msum_8 1000000
R_L1_m_44_8 pixel_44 l1_msum_8 1000000
R_L1_m_45_8 pixel_45 l1_msum_8 66037.735849056597
R_L1_m_46_8 pixel_46 l1_msum_8 1000000
R_L1_m_47_8 pixel_47 l1_msum_8 16055.045871559634
R_L1_m_48_8 pixel_48 l1_msum_8 1000000
R_L1_m_49_8 pixel_49 l1_msum_8 1000000
R_L1_m_50_8 pixel_50 l1_msum_8 1000000
R_L1_m_51_8 pixel_51 l1_msum_8 1000000
R_L1_m_52_8 pixel_52 l1_msum_8 1000000
R_L1_m_53_8 pixel_53 l1_msum_8 40697.674418604649
R_L1_m_54_8 pixel_54 l1_msum_8 28112.449799196787
R_L1_m_55_8 pixel_55 l1_msum_8 29411.764705882353
R_L1_m_56_8 pixel_56 l1_msum_8 59829.059829059821
R_L1_m_57_8 pixel_57 l1_msum_8 29411.764705882353
R_L1_m_58_8 pixel_58 l1_msum_8 54687.499999999993
R_L1_m_59_8 pixel_59 l1_msum_8 50359.712230215831
R_L1_m_60_8 pixel_60 l1_msum_8 38251.366120218576
R_L1_m_61_8 pixel_61 l1_msum_8 23890.784982935158
R_L1_m_62_8 pixel_62 l1_msum_8 18918.91891891892
R_L1_m_63_8 pixel_63 l1_msum_8 1000000
E_TIA_L1_m_8 l1_mout_8 0 0 l1_msum_8 100000000
R_FB_L1_m_8 l1_mout_8 l1_msum_8 1000
B_NEURON_L1_8 hidden_8 0 V={0.01*max(((V(l1_mout_8)-V(l1_pout_8))/0.0030903275574088963+(-0.010318334214389324)),0)}
R_L1_p_0_9 pixel_0 l1_psum_9 1000000
R_L1_p_1_9 pixel_1 l1_psum_9 1000000
R_L1_p_2_9 pixel_2 l1_psum_9 1000000
R_L1_p_3_9 pixel_3 l1_psum_9 1000000
R_L1_p_4_9 pixel_4 l1_psum_9 1000000
R_L1_p_5_9 pixel_5 l1_psum_9 1000000
R_L1_p_6_9 pixel_6 l1_psum_9 46666.666666666664
R_L1_p_7_9 pixel_7 l1_psum_9 95890.410958904104
R_L1_p_8_9 pixel_8 l1_psum_9 1000000
R_L1_p_9_9 pixel_9 l1_psum_9 1000000
R_L1_p_10_9 pixel_10 l1_psum_9 1000000
R_L1_p_11_9 pixel_11 l1_psum_9 1000000
R_L1_p_12_9 pixel_12 l1_psum_9 1000000
R_L1_p_13_9 pixel_13 l1_psum_9 241379.31034482759
R_L1_p_14_9 pixel_14 l1_psum_9 54687.499999999993
R_L1_p_15_9 pixel_15 l1_psum_9 24822.695035460994
R_L1_p_16_9 pixel_16 l1_psum_9 1000000
R_L1_p_17_9 pixel_17 l1_psum_9 66037.735849056597
R_L1_p_18_9 pixel_18 l1_psum_9 59829.059829059821
R_L1_p_19_9 pixel_19 l1_psum_9 95890.410958904104
R_L1_p_20_9 pixel_20 l1_psum_9 1000000
R_L1_p_21_9 pixel_21 l1_psum_9 1000000
R_L1_p_22_9 pixel_22 l1_psum_9 59829.059829059821
R_L1_p_23_9 pixel_23 l1_psum_9 32407.407407407409
R_L1_p_24_9 pixel_24 l1_psum_9 1000000
R_L1_p_25_9 pixel_25 l1_psum_9 29411.764705882353
R_L1_p_26_9 pixel_26 l1_psum_9 28112.449799196787
R_L1_p_27_9 pixel_27 l1_psum_9 83333.333333333328
R_L1_p_28_9 pixel_28 l1_psum_9 1000000
R_L1_p_29_9 pixel_29 l1_psum_9 175000.00000000003
R_L1_p_30_9 pixel_30 l1_psum_9 1000000
R_L1_p_31_9 pixel_31 l1_psum_9 1000000
R_L1_p_32_9 pixel_32 l1_psum_9 50359.712230215831
R_L1_p_33_9 pixel_33 l1_psum_9 1000000
R_L1_p_34_9 pixel_34 l1_psum_9 1000000
R_L1_p_35_9 pixel_35 l1_psum_9 1000000
R_L1_p_36_9 pixel_36 l1_psum_9 388888.88888888888
R_L1_p_37_9 pixel_37 l1_psum_9 1000000
R_L1_p_38_9 pixel_38 l1_psum_9 1000000
R_L1_p_39_9 pixel_39 l1_psum_9 1000000
R_L1_p_40_9 pixel_40 l1_psum_9 1000000
R_L1_p_41_9 pixel_41 l1_psum_9 1000000
R_L1_p_42_9 pixel_42 l1_psum_9 1000000
R_L1_p_43_9 pixel_43 l1_psum_9 59829.059829059821
R_L1_p_44_9 pixel_44 l1_psum_9 46666.666666666664
R_L1_p_45_9 pixel_45 l1_psum_9 1000000
R_L1_p_46_9 pixel_46 l1_psum_9 1000000
R_L1_p_47_9 pixel_47 l1_psum_9 54687.499999999993
R_L1_p_48_9 pixel_48 l1_psum_9 1000000
R_L1_p_49_9 pixel_49 l1_psum_9 1000000
R_L1_p_50_9 pixel_50 l1_psum_9 137254.90196078431
R_L1_p_51_9 pixel_51 l1_psum_9 95890.410958904104
R_L1_p_52_9 pixel_52 l1_psum_9 83333.333333333328
R_L1_p_53_9 pixel_53 l1_psum_9 175000.00000000003
R_L1_p_54_9 pixel_54 l1_psum_9 83333.333333333328
R_L1_p_55_9 pixel_55 l1_psum_9 66037.735849056597
R_L1_p_56_9 pixel_56 l1_psum_9 95890.410958904104
R_L1_p_57_9 pixel_57 l1_psum_9 1000000
R_L1_p_58_9 pixel_58 l1_psum_9 1000000
R_L1_p_59_9 pixel_59 l1_psum_9 1000000
R_L1_p_60_9 pixel_60 l1_psum_9 73684.210526315786
R_L1_p_61_9 pixel_61 l1_psum_9 43478.260869565216
R_L1_p_62_9 pixel_62 l1_psum_9 43478.260869565216
R_L1_p_63_9 pixel_63 l1_psum_9 1000000
E_TIA_L1_p_9 l1_pout_9 0 0 l1_psum_9 100000000
R_FB_L1_p_9 l1_pout_9 l1_psum_9 1000
R_L1_m_0_9 pixel_0 l1_msum_9 1000000
R_L1_m_1_9 pixel_1 l1_msum_9 54687.499999999993
R_L1_m_2_9 pixel_2 l1_msum_9 19498.607242339833
R_L1_m_3_9 pixel_3 l1_msum_9 13645.22417153996
R_L1_m_4_9 pixel_4 l1_msum_9 30837.004405286345
R_L1_m_5_9 pixel_5 l1_msum_9 1000000
R_L1_m_6_9 pixel_6 l1_msum_9 1000000
R_L1_m_7_9 pixel_7 l1_msum_9 1000000
R_L1_m_8_9 pixel_8 l1_msum_9 50359.712230215831
R_L1_m_9_9 pixel_9 l1_msum_9 73684.210526315786
R_L1_m_10_9 pixel_10 l1_msum_9 137254.90196078431
R_L1_m_11_9 pixel_11 l1_msum_9 137254.90196078431
R_L1_m_12_9 pixel_12 l1_msum_9 95890.410958904104
R_L1_m_13_9 pixel_13 l1_msum_9 1000000
R_L1_m_14_9 pixel_14 l1_msum_9 1000000
R_L1_m_15_9 pixel_15 l1_msum_9 1000000
R_L1_m_16_9 pixel_16 l1_msum_9 388888.88888888888
R_L1_m_17_9 pixel_17 l1_msum_9 1000000
R_L1_m_18_9 pixel_18 l1_msum_9 1000000
R_L1_m_19_9 pixel_19 l1_msum_9 1000000
R_L1_m_20_9 pixel_20 l1_msum_9 175000.00000000003
R_L1_m_21_9 pixel_21 l1_msum_9 241379.31034482759
R_L1_m_22_9 pixel_22 l1_msum_9 1000000
R_L1_m_23_9 pixel_23 l1_msum_9 1000000
R_L1_m_24_9 pixel_24 l1_msum_9 1000000
R_L1_m_25_9 pixel_25 l1_msum_9 1000000
R_L1_m_26_9 pixel_26 l1_msum_9 1000000
R_L1_m_27_9 pixel_27 l1_msum_9 1000000
R_L1_m_28_9 pixel_28 l1_msum_9 95890.410958904104
R_L1_m_29_9 pixel_29 l1_msum_9 1000000
R_L1_m_30_9 pixel_30 l1_msum_9 38251.366120218576
R_L1_m_31_9 pixel_31 l1_msum_9 38251.366120218576
R_L1_m_32_9 pixel_32 l1_msum_9 1000000
R_L1_m_33_9 pixel_33 l1_msum_9 38251.366120218576
R_L1_m_34_9 pixel_34 l1_msum_9 23026.315789473687
R_L1_m_35_9 pixel_35 l1_msum_9 34146.341463414632
R_L1_m_36_9 pixel_36 l1_msum_9 1000000
R_L1_m_37_9 pixel_37 l1_msum_9 95890.410958904104
R_L1_m_38_9 pixel_38 l1_msum_9 241379.31034482759
R_L1_m_39_9 pixel_39 l1_msum_9 137254.90196078431
R_L1_m_40_9 pixel_40 l1_msum_9 40697.674418604649
R_L1_m_41_9 pixel_41 l1_msum_9 46666.666666666664
R_L1_m_42_9 pixel_42 l1_msum_9 36082.474226804123
R_L1_m_43_9 pixel_43 l1_msum_9 1000000
R_L1_m_44_9 pixel_44 l1_msum_9 1000000
R_L1_m_45_9 pixel_45 l1_msum_9 241379.31034482759
R_L1_m_46_9 pixel_46 l1_msum_9 112903.22580645159
R_L1_m_47_9 pixel_47 l1_msum_9 1000000
R_L1_m_48_9 pixel_48 l1_msum_9 38251.366120218576
R_L1_m_49_9 pixel_49 l1_msum_9 66037.735849056597
R_L1_m_50_9 pixel_50 l1_msum_9 1000000
R_L1_m_51_9 pixel_51 l1_msum_9 1000000
R_L1_m_52_9 pixel_52 l1_msum_9 1000000
R_L1_m_53_9 pixel_53 l1_msum_9 1000000
R_L1_m_54_9 pixel_54 l1_msum_9 1000000
R_L1_m_55_9 pixel_55 l1_msum_9 1000000
R_L1_m_56_9 pixel_56 l1_msum_9 1000000
R_L1_m_57_9 pixel_57 l1_msum_9 43478.260869565216
R_L1_m_58_9 pixel_58 l1_msum_9 137254.90196078431
R_L1_m_59_9 pixel_59 l1_msum_9 388888.88888888888
R_L1_m_60_9 pixel_60 l1_msum_9 1000000
R_L1_m_61_9 pixel_61 l1_msum_9 1000000
R_L1_m_62_9 pixel_62 l1_msum_9 1000000
R_L1_m_63_9 pixel_63 l1_msum_9 83333.333333333328
E_TIA_L1_m_9 l1_mout_9 0 0 l1_msum_9 100000000
R_FB_L1_m_9 l1_mout_9 l1_msum_9 1000
B_NEURON_L1_9 hidden_9 0 V={0.01*max(((V(l1_mout_9)-V(l1_pout_9))/0.0030903275574088963+(0.19145224988460541)),0)}
R_L1_p_0_10 pixel_0 l1_psum_10 43478.260869565216
R_L1_p_1_10 pixel_1 l1_psum_10 1000000
R_L1_p_2_10 pixel_2 l1_psum_10 1000000
R_L1_p_3_10 pixel_3 l1_psum_10 175000.00000000003
R_L1_p_4_10 pixel_4 l1_psum_10 38251.366120218576
R_L1_p_5_10 pixel_5 l1_psum_10 1000000
R_L1_p_6_10 pixel_6 l1_psum_10 1000000
R_L1_p_7_10 pixel_7 l1_psum_10 1000000
R_L1_p_8_10 pixel_8 l1_psum_10 83333.333333333328
R_L1_p_9_10 pixel_9 l1_psum_10 241379.31034482759
R_L1_p_10_10 pixel_10 l1_psum_10 38251.366120218576
R_L1_p_11_10 pixel_11 l1_psum_10 50359.712230215831
R_L1_p_12_10 pixel_12 l1_psum_10 1000000
R_L1_p_13_10 pixel_13 l1_psum_10 1000000
R_L1_p_14_10 pixel_14 l1_psum_10 1000000
R_L1_p_15_10 pixel_15 l1_psum_10 112903.22580645159
R_L1_p_16_10 pixel_16 l1_psum_10 388888.88888888888
R_L1_p_17_10 pixel_17 l1_psum_10 50359.712230215831
R_L1_p_18_10 pixel_18 l1_psum_10 20771.51335311573
R_L1_p_19_10 pixel_19 l1_psum_10 1000000
R_L1_p_20_10 pixel_20 l1_psum_10 1000000
R_L1_p_21_10 pixel_21 l1_psum_10 66037.735849056597
R_L1_p_22_10 pixel_22 l1_psum_10 83333.333333333328
R_L1_p_23_10 pixel_23 l1_psum_10 241379.31034482759
R_L1_p_24_10 pixel_24 l1_psum_10 66037.735849056597
R_L1_p_25_10 pixel_25 l1_psum_10 73684.210526315786
R_L1_p_26_10 pixel_26 l1_psum_10 36082.474226804123
R_L1_p_27_10 pixel_27 l1_psum_10 1000000
R_L1_p_28_10 pixel_28 l1_psum_10 1000000
R_L1_p_29_10 pixel_29 l1_psum_10 1000000
R_L1_p_30_10 pixel_30 l1_psum_10 175000.00000000003
R_L1_p_31_10 pixel_31 l1_psum_10 38251.366120218576
R_L1_p_32_10 pixel_32 l1_psum_10 112903.22580645159
R_L1_p_33_10 pixel_33 l1_psum_10 73684.210526315786
R_L1_p_34_10 pixel_34 l1_psum_10 38251.366120218576
R_L1_p_35_10 pixel_35 l1_psum_10 1000000
R_L1_p_36_10 pixel_36 l1_psum_10 1000000
R_L1_p_37_10 pixel_37 l1_psum_10 241379.31034482759
R_L1_p_38_10 pixel_38 l1_psum_10 241379.31034482759
R_L1_p_39_10 pixel_39 l1_psum_10 29411.764705882353
R_L1_p_40_10 pixel_40 l1_psum_10 66037.735849056597
R_L1_p_41_10 pixel_41 l1_psum_10 1000000
R_L1_p_42_10 pixel_42 l1_psum_10 241379.31034482759
R_L1_p_43_10 pixel_43 l1_psum_10 388888.88888888888
R_L1_p_44_10 pixel_44 l1_psum_10 54687.499999999993
R_L1_p_45_10 pixel_45 l1_psum_10 50359.712230215831
R_L1_p_46_10 pixel_46 l1_psum_10 73684.210526315786
R_L1_p_47_10 pixel_47 l1_psum_10 1000000
R_L1_p_48_10 pixel_48 l1_psum_10 137254.90196078431
R_L1_p_49_10 pixel_49 l1_psum_10 46666.666666666664
R_L1_p_50_10 pixel_50 l1_psum_10 95890.410958904104
R_L1_p_51_10 pixel_51 l1_psum_10 1000000
R_L1_p_52_10 pixel_52 l1_psum_10 241379.31034482759
R_L1_p_53_10 pixel_53 l1_psum_10 1000000
R_L1_p_54_10 pixel_54 l1_psum_10 1000000
R_L1_p_55_10 pixel_55 l1_psum_10 32407.407407407409
R_L1_p_56_10 pixel_56 l1_psum_10 46666.666666666664
R_L1_p_57_10 pixel_57 l1_psum_10 1000000
R_L1_p_58_10 pixel_58 l1_psum_10 137254.90196078431
R_L1_p_59_10 pixel_59 l1_psum_10 137254.90196078431
R_L1_p_60_10 pixel_60 l1_psum_10 1000000
R_L1_p_61_10 pixel_61 l1_psum_10 1000000
R_L1_p_62_10 pixel_62 l1_psum_10 1000000
R_L1_p_63_10 pixel_63 l1_psum_10 66037.735849056597
E_TIA_L1_p_10 l1_pout_10 0 0 l1_psum_10 100000000
R_FB_L1_p_10 l1_pout_10 l1_psum_10 1000
R_L1_m_0_10 pixel_0 l1_msum_10 1000000
R_L1_m_1_10 pixel_1 l1_msum_10 73684.210526315786
R_L1_m_2_10 pixel_2 l1_msum_10 40697.674418604649
R_L1_m_3_10 pixel_3 l1_msum_10 1000000
R_L1_m_4_10 pixel_4 l1_msum_10 1000000
R_L1_m_5_10 pixel_5 l1_msum_10 66037.735849056597
R_L1_m_6_10 pixel_6 l1_msum_10 241379.31034482759
R_L1_m_7_10 pixel_7 l1_msum_10 1000000
R_L1_m_8_10 pixel_8 l1_msum_10 1000000
R_L1_m_9_10 pixel_9 l1_msum_10 1000000
R_L1_m_10_10 pixel_10 l1_msum_10 1000000
R_L1_m_11_10 pixel_11 l1_msum_10 1000000
R_L1_m_12_10 pixel_12 l1_msum_10 241379.31034482759
R_L1_m_13_10 pixel_13 l1_msum_10 95890.410958904104
R_L1_m_14_10 pixel_14 l1_msum_10 388888.88888888888
R_L1_m_15_10 pixel_15 l1_msum_10 1000000
R_L1_m_16_10 pixel_16 l1_msum_10 1000000
R_L1_m_17_10 pixel_17 l1_msum_10 1000000
R_L1_m_18_10 pixel_18 l1_msum_10 1000000
R_L1_m_19_10 pixel_19 l1_msum_10 34146.341463414632
R_L1_m_20_10 pixel_20 l1_msum_10 73684.210526315786
R_L1_m_21_10 pixel_21 l1_msum_10 1000000
R_L1_m_22_10 pixel_22 l1_msum_10 1000000
R_L1_m_23_10 pixel_23 l1_msum_10 1000000
R_L1_m_24_10 pixel_24 l1_msum_10 1000000
R_L1_m_25_10 pixel_25 l1_msum_10 1000000
R_L1_m_26_10 pixel_26 l1_msum_10 1000000
R_L1_m_27_10 pixel_27 l1_msum_10 15283.842794759827
R_L1_m_28_10 pixel_28 l1_msum_10 388888.88888888888
R_L1_m_29_10 pixel_29 l1_msum_10 83333.333333333328
R_L1_m_30_10 pixel_30 l1_msum_10 1000000
R_L1_m_31_10 pixel_31 l1_msum_10 1000000
R_L1_m_32_10 pixel_32 l1_msum_10 1000000
R_L1_m_33_10 pixel_33 l1_msum_10 1000000
R_L1_m_34_10 pixel_34 l1_msum_10 1000000
R_L1_m_35_10 pixel_35 l1_msum_10 40697.674418604649
R_L1_m_36_10 pixel_36 l1_msum_10 388888.88888888888
R_L1_m_37_10 pixel_37 l1_msum_10 1000000
R_L1_m_38_10 pixel_38 l1_msum_10 1000000
R_L1_m_39_10 pixel_39 l1_msum_10 1000000
R_L1_m_40_10 pixel_40 l1_msum_10 1000000
R_L1_m_41_10 pixel_41 l1_msum_10 95890.410958904104
R_L1_m_42_10 pixel_42 l1_msum_10 1000000
R_L1_m_43_10 pixel_43 l1_msum_10 1000000
R_L1_m_44_10 pixel_44 l1_msum_10 1000000
R_L1_m_45_10 pixel_45 l1_msum_10 1000000
R_L1_m_46_10 pixel_46 l1_msum_10 1000000
R_L1_m_47_10 pixel_47 l1_msum_10 59829.059829059821
R_L1_m_48_10 pixel_48 l1_msum_10 1000000
R_L1_m_49_10 pixel_49 l1_msum_10 1000000
R_L1_m_50_10 pixel_50 l1_msum_10 1000000
R_L1_m_51_10 pixel_51 l1_msum_10 241379.31034482759
R_L1_m_52_10 pixel_52 l1_msum_10 1000000
R_L1_m_53_10 pixel_53 l1_msum_10 1000000
R_L1_m_54_10 pixel_54 l1_msum_10 1000000
R_L1_m_55_10 pixel_55 l1_msum_10 1000000
R_L1_m_56_10 pixel_56 l1_msum_10 1000000
R_L1_m_57_10 pixel_57 l1_msum_10 388888.88888888888
R_L1_m_58_10 pixel_58 l1_msum_10 1000000
R_L1_m_59_10 pixel_59 l1_msum_10 1000000
R_L1_m_60_10 pixel_60 l1_msum_10 38251.366120218576
R_L1_m_61_10 pixel_61 l1_msum_10 46666.666666666664
R_L1_m_62_10 pixel_62 l1_msum_10 46666.666666666664
R_L1_m_63_10 pixel_63 l1_msum_10 1000000
E_TIA_L1_m_10 l1_mout_10 0 0 l1_msum_10 100000000
R_FB_L1_m_10 l1_mout_10 l1_msum_10 1000
B_NEURON_L1_10 hidden_10 0 V={0.01*max(((V(l1_mout_10)-V(l1_pout_10))/0.0030903275574088963+(0.12989620864391327)),0)}
R_L1_p_0_11 pixel_0 l1_psum_11 1000000
R_L1_p_1_11 pixel_1 l1_psum_11 112903.22580645159
R_L1_p_2_11 pixel_2 l1_psum_11 1000000
R_L1_p_3_11 pixel_3 l1_psum_11 1000000
R_L1_p_4_11 pixel_4 l1_psum_11 175000.00000000003
R_L1_p_5_11 pixel_5 l1_psum_11 1000000
R_L1_p_6_11 pixel_6 l1_psum_11 388888.88888888888
R_L1_p_7_11 pixel_7 l1_psum_11 40697.674418604649
R_L1_p_8_11 pixel_8 l1_psum_11 1000000
R_L1_p_9_11 pixel_9 l1_psum_11 137254.90196078431
R_L1_p_10_11 pixel_10 l1_psum_11 1000000
R_L1_p_11_11 pixel_11 l1_psum_11 112903.22580645159
R_L1_p_12_11 pixel_12 l1_psum_11 388888.88888888888
R_L1_p_13_11 pixel_13 l1_psum_11 1000000
R_L1_p_14_11 pixel_14 l1_psum_11 1000000
R_L1_p_15_11 pixel_15 l1_psum_11 1000000
R_L1_p_16_11 pixel_16 l1_psum_11 1000000
R_L1_p_17_11 pixel_17 l1_psum_11 73684.210526315786
R_L1_p_18_11 pixel_18 l1_psum_11 175000.00000000003
R_L1_p_19_11 pixel_19 l1_psum_11 1000000
R_L1_p_20_11 pixel_20 l1_psum_11 29411.764705882353
R_L1_p_21_11 pixel_21 l1_psum_11 1000000
R_L1_p_22_11 pixel_22 l1_psum_11 1000000
R_L1_p_23_11 pixel_23 l1_psum_11 1000000
R_L1_p_24_11 pixel_24 l1_psum_11 1000000
R_L1_p_25_11 pixel_25 l1_psum_11 1000000
R_L1_p_26_11 pixel_26 l1_psum_11 1000000
R_L1_p_27_11 pixel_27 l1_psum_11 1000000
R_L1_p_28_11 pixel_28 l1_psum_11 83333.333333333328
R_L1_p_29_11 pixel_29 l1_psum_11 1000000
R_L1_p_30_11 pixel_30 l1_psum_11 59829.059829059821
R_L1_p_31_11 pixel_31 l1_psum_11 30837.004405286345
R_L1_p_32_11 pixel_32 l1_psum_11 1000000
R_L1_p_33_11 pixel_33 l1_psum_11 1000000
R_L1_p_34_11 pixel_34 l1_psum_11 112903.22580645159
R_L1_p_35_11 pixel_35 l1_psum_11 20114.942528735632
R_L1_p_36_11 pixel_36 l1_psum_11 137254.90196078431
R_L1_p_37_11 pixel_37 l1_psum_11 59829.059829059821
R_L1_p_38_11 pixel_38 l1_psum_11 83333.333333333328
R_L1_p_39_11 pixel_39 l1_psum_11 1000000
R_L1_p_40_11 pixel_40 l1_psum_11 1000000
R_L1_p_41_11 pixel_41 l1_psum_11 1000000
R_L1_p_42_11 pixel_42 l1_psum_11 1000000
R_L1_p_43_11 pixel_43 l1_psum_11 73684.210526315786
R_L1_p_44_11 pixel_44 l1_psum_11 73684.210526315786
R_L1_p_45_11 pixel_45 l1_psum_11 1000000
R_L1_p_46_11 pixel_46 l1_psum_11 59829.059829059821
R_L1_p_47_11 pixel_47 l1_psum_11 137254.90196078431
R_L1_p_48_11 pixel_48 l1_psum_11 1000000
R_L1_p_49_11 pixel_49 l1_psum_11 1000000
R_L1_p_50_11 pixel_50 l1_psum_11 1000000
R_L1_p_51_11 pixel_51 l1_psum_11 1000000
R_L1_p_52_11 pixel_52 l1_psum_11 137254.90196078431
R_L1_p_53_11 pixel_53 l1_psum_11 1000000
R_L1_p_54_11 pixel_54 l1_psum_11 1000000
R_L1_p_55_11 pixel_55 l1_psum_11 1000000
R_L1_p_56_11 pixel_56 l1_psum_11 1000000
R_L1_p_57_11 pixel_57 l1_psum_11 137254.90196078431
R_L1_p_58_11 pixel_58 l1_psum_11 1000000
R_L1_p_59_11 pixel_59 l1_psum_11 1000000
R_L1_p_60_11 pixel_60 l1_psum_11 1000000
R_L1_p_61_11 pixel_61 l1_psum_11 1000000
R_L1_p_62_11 pixel_62 l1_psum_11 1000000
R_L1_p_63_11 pixel_63 l1_psum_11 1000000
E_TIA_L1_p_11 l1_pout_11 0 0 l1_psum_11 100000000
R_FB_L1_p_11 l1_pout_11 l1_psum_11 1000
R_L1_m_0_11 pixel_0 l1_msum_11 388888.88888888888
R_L1_m_1_11 pixel_1 l1_msum_11 1000000
R_L1_m_2_11 pixel_2 l1_msum_11 26923.076923076922
R_L1_m_3_11 pixel_3 l1_msum_11 112903.22580645159
R_L1_m_4_11 pixel_4 l1_msum_11 1000000
R_L1_m_5_11 pixel_5 l1_msum_11 50359.712230215831
R_L1_m_6_11 pixel_6 l1_msum_11 1000000
R_L1_m_7_11 pixel_7 l1_msum_11 1000000
R_L1_m_8_11 pixel_8 l1_msum_11 241379.31034482759
R_L1_m_9_11 pixel_9 l1_msum_11 1000000
R_L1_m_10_11 pixel_10 l1_msum_11 137254.90196078431
R_L1_m_11_11 pixel_11 l1_msum_11 1000000
R_L1_m_12_11 pixel_12 l1_msum_11 1000000
R_L1_m_13_11 pixel_13 l1_msum_11 66037.735849056597
R_L1_m_14_11 pixel_14 l1_msum_11 29411.764705882353
R_L1_m_15_11 pixel_15 l1_msum_11 388888.88888888888
R_L1_m_16_11 pixel_16 l1_msum_11 95890.410958904104
R_L1_m_17_11 pixel_17 l1_msum_11 1000000
R_L1_m_18_11 pixel_18 l1_msum_11 1000000
R_L1_m_19_11 pixel_19 l1_msum_11 83333.333333333328
R_L1_m_20_11 pixel_20 l1_msum_11 1000000
R_L1_m_21_11 pixel_21 l1_msum_11 59829.059829059821
R_L1_m_22_11 pixel_22 l1_msum_11 23026.315789473687
R_L1_m_23_11 pixel_23 l1_msum_11 137254.90196078431
R_L1_m_24_11 pixel_24 l1_msum_11 59829.059829059821
R_L1_m_25_11 pixel_25 l1_msum_11 50359.712230215831
R_L1_m_26_11 pixel_26 l1_msum_11 24822.695035460994
R_L1_m_27_11 pixel_27 l1_msum_11 137254.90196078431
R_L1_m_28_11 pixel_28 l1_msum_11 1000000
R_L1_m_29_11 pixel_29 l1_msum_11 50359.712230215831
R_L1_m_30_11 pixel_30 l1_msum_11 1000000
R_L1_m_31_11 pixel_31 l1_msum_11 1000000
R_L1_m_32_11 pixel_32 l1_msum_11 54687.499999999993
R_L1_m_33_11 pixel_33 l1_msum_11 137254.90196078431
R_L1_m_34_11 pixel_34 l1_msum_11 1000000
R_L1_m_35_11 pixel_35 l1_msum_11 1000000
R_L1_m_36_11 pixel_36 l1_msum_11 1000000
R_L1_m_37_11 pixel_37 l1_msum_11 1000000
R_L1_m_38_11 pixel_38 l1_msum_11 1000000
R_L1_m_39_11 pixel_39 l1_msum_11 50359.712230215831
R_L1_m_40_11 pixel_40 l1_msum_11 95890.410958904104
R_L1_m_41_11 pixel_41 l1_msum_11 34146.341463414632
R_L1_m_42_11 pixel_42 l1_msum_11 32407.407407407409
R_L1_m_43_11 pixel_43 l1_msum_11 1000000
R_L1_m_44_11 pixel_44 l1_msum_11 1000000
R_L1_m_45_11 pixel_45 l1_msum_11 175000.00000000003
R_L1_m_46_11 pixel_46 l1_msum_11 1000000
R_L1_m_47_11 pixel_47 l1_msum_11 1000000
R_L1_m_48_11 pixel_48 l1_msum_11 112903.22580645159
R_L1_m_49_11 pixel_49 l1_msum_11 54687.499999999993
R_L1_m_50_11 pixel_50 l1_msum_11 25830.258302583028
R_L1_m_51_11 pixel_51 l1_msum_11 137254.90196078431
R_L1_m_52_11 pixel_52 l1_msum_11 1000000
R_L1_m_53_11 pixel_53 l1_msum_11 30837.004405286345
R_L1_m_54_11 pixel_54 l1_msum_11 40697.674418604649
R_L1_m_55_11 pixel_55 l1_msum_11 50359.712230215831
R_L1_m_56_11 pixel_56 l1_msum_11 388888.88888888888
R_L1_m_57_11 pixel_57 l1_msum_11 1000000
R_L1_m_58_11 pixel_58 l1_msum_11 66037.735849056597
R_L1_m_59_11 pixel_59 l1_msum_11 30837.004405286345
R_L1_m_60_11 pixel_60 l1_msum_11 24822.695035460994
R_L1_m_61_11 pixel_61 l1_msum_11 17857.142857142859
R_L1_m_62_11 pixel_62 l1_msum_11 18918.91891891892
R_L1_m_63_11 pixel_63 l1_msum_11 1000000
E_TIA_L1_m_11 l1_mout_11 0 0 l1_msum_11 100000000
R_FB_L1_m_11 l1_mout_11 l1_msum_11 1000
B_NEURON_L1_11 hidden_11 0 V={0.01*max(((V(l1_mout_11)-V(l1_pout_11))/0.0030903275574088963+(-0.19880473613739014)),0)}
R_L1_p_0_12 pixel_0 l1_psum_12 112903.22580645159
R_L1_p_1_12 pixel_1 l1_psum_12 1000000
R_L1_p_2_12 pixel_2 l1_psum_12 26923.076923076922
R_L1_p_3_12 pixel_3 l1_psum_12 25830.258302583028
R_L1_p_4_12 pixel_4 l1_psum_12 34146.341463414632
R_L1_p_5_12 pixel_5 l1_psum_12 34146.341463414632
R_L1_p_6_12 pixel_6 l1_psum_12 29411.764705882353
R_L1_p_7_12 pixel_7 l1_psum_12 29411.764705882353
R_L1_p_8_12 pixel_8 l1_psum_12 1000000
R_L1_p_9_12 pixel_9 l1_psum_12 1000000
R_L1_p_10_12 pixel_10 l1_psum_12 388888.88888888888
R_L1_p_11_12 pixel_11 l1_psum_12 1000000
R_L1_p_12_12 pixel_12 l1_psum_12 83333.333333333328
R_L1_p_13_12 pixel_13 l1_psum_12 40697.674418604649
R_L1_p_14_12 pixel_14 l1_psum_12 83333.333333333328
R_L1_p_15_12 pixel_15 l1_psum_12 73684.210526315786
R_L1_p_16_12 pixel_16 l1_psum_12 1000000
R_L1_p_17_12 pixel_17 l1_psum_12 1000000
R_L1_p_18_12 pixel_18 l1_psum_12 1000000
R_L1_p_19_12 pixel_19 l1_psum_12 1000000
R_L1_p_20_12 pixel_20 l1_psum_12 241379.31034482759
R_L1_p_21_12 pixel_21 l1_psum_12 1000000
R_L1_p_22_12 pixel_22 l1_psum_12 83333.333333333328
R_L1_p_23_12 pixel_23 l1_psum_12 38251.366120218576
R_L1_p_24_12 pixel_24 l1_psum_12 112903.22580645159
R_L1_p_25_12 pixel_25 l1_psum_12 1000000
R_L1_p_26_12 pixel_26 l1_psum_12 1000000
R_L1_p_27_12 pixel_27 l1_psum_12 175000.00000000003
R_L1_p_28_12 pixel_28 l1_psum_12 1000000
R_L1_p_29_12 pixel_29 l1_psum_12 1000000
R_L1_p_30_12 pixel_30 l1_psum_12 1000000
R_L1_p_31_12 pixel_31 l1_psum_12 32407.407407407409
R_L1_p_32_12 pixel_32 l1_psum_12 1000000
R_L1_p_33_12 pixel_33 l1_psum_12 1000000
R_L1_p_34_12 pixel_34 l1_psum_12 1000000
R_L1_p_35_12 pixel_35 l1_psum_12 137254.90196078431
R_L1_p_36_12 pixel_36 l1_psum_12 1000000
R_L1_p_37_12 pixel_37 l1_psum_12 1000000
R_L1_p_38_12 pixel_38 l1_psum_12 1000000
R_L1_p_39_12 pixel_39 l1_psum_12 59829.059829059821
R_L1_p_40_12 pixel_40 l1_psum_12 175000.00000000003
R_L1_p_41_12 pixel_41 l1_psum_12 241379.31034482759
R_L1_p_42_12 pixel_42 l1_psum_12 1000000
R_L1_p_43_12 pixel_43 l1_psum_12 241379.31034482759
R_L1_p_44_12 pixel_44 l1_psum_12 83333.333333333328
R_L1_p_45_12 pixel_45 l1_psum_12 73684.210526315786
R_L1_p_46_12 pixel_46 l1_psum_12 73684.210526315786
R_L1_p_47_12 pixel_47 l1_psum_12 38251.366120218576
R_L1_p_48_12 pixel_48 l1_psum_12 22222.222222222223
R_L1_p_49_12 pixel_49 l1_psum_12 66037.735849056597
R_L1_p_50_12 pixel_50 l1_psum_12 32407.407407407409
R_L1_p_51_12 pixel_51 l1_psum_12 28112.449799196787
R_L1_p_52_12 pixel_52 l1_psum_12 18372.70341207349
R_L1_p_53_12 pixel_53 l1_psum_12 26923.076923076922
R_L1_p_54_12 pixel_54 l1_psum_12 23890.784982935158
R_L1_p_55_12 pixel_55 l1_psum_12 22222.222222222223
R_L1_p_56_12 pixel_56 l1_psum_12 1000000
R_L1_p_57_12 pixel_57 l1_psum_12 1000000
R_L1_p_58_12 pixel_58 l1_psum_12 1000000
R_L1_p_59_12 pixel_59 l1_psum_12 1000000
R_L1_p_60_12 pixel_60 l1_psum_12 1000000
R_L1_p_61_12 pixel_61 l1_psum_12 388888.88888888888
R_L1_p_62_12 pixel_62 l1_psum_12 1000000
R_L1_p_63_12 pixel_63 l1_psum_12 66037.735849056597
E_TIA_L1_p_12 l1_pout_12 0 0 l1_psum_12 100000000
R_FB_L1_p_12 l1_pout_12 l1_psum_12 1000
R_L1_m_0_12 pixel_0 l1_msum_12 1000000
R_L1_m_1_12 pixel_1 l1_msum_12 112903.22580645159
R_L1_m_2_12 pixel_2 l1_msum_12 1000000
R_L1_m_3_12 pixel_3 l1_msum_12 1000000
R_L1_m_4_12 pixel_4 l1_msum_12 1000000
R_L1_m_5_12 pixel_5 l1_msum_12 1000000
R_L1_m_6_12 pixel_6 l1_msum_12 1000000
R_L1_m_7_12 pixel_7 l1_msum_12 1000000
R_L1_m_8_12 pixel_8 l1_msum_12 40697.674418604649
R_L1_m_9_12 pixel_9 l1_msum_12 38251.366120218576
R_L1_m_10_12 pixel_10 l1_msum_12 1000000
R_L1_m_11_12 pixel_11 l1_msum_12 388888.88888888888
R_L1_m_12_12 pixel_12 l1_msum_12 1000000
R_L1_m_13_12 pixel_13 l1_msum_12 1000000
R_L1_m_14_12 pixel_14 l1_msum_12 1000000
R_L1_m_15_12 pixel_15 l1_msum_12 1000000
R_L1_m_16_12 pixel_16 l1_msum_12 54687.499999999993
R_L1_m_17_12 pixel_17 l1_msum_12 137254.90196078431
R_L1_m_18_12 pixel_18 l1_msum_12 1000000
R_L1_m_19_12 pixel_19 l1_msum_12 1000000
R_L1_m_20_12 pixel_20 l1_msum_12 1000000
R_L1_m_21_12 pixel_21 l1_msum_12 112903.22580645159
R_L1_m_22_12 pixel_22 l1_msum_12 1000000
R_L1_m_23_12 pixel_23 l1_msum_12 1000000
R_L1_m_24_12 pixel_24 l1_msum_12 1000000
R_L1_m_25_12 pixel_25 l1_msum_12 137254.90196078431
R_L1_m_26_12 pixel_26 l1_msum_12 175000.00000000003
R_L1_m_27_12 pixel_27 l1_msum_12 1000000
R_L1_m_28_12 pixel_28 l1_msum_12 43478.260869565216
R_L1_m_29_12 pixel_29 l1_msum_12 66037.735849056597
R_L1_m_30_12 pixel_30 l1_msum_12 73684.210526315786
R_L1_m_31_12 pixel_31 l1_msum_12 1000000
R_L1_m_32_12 pixel_32 l1_msum_12 66037.735849056597
R_L1_m_33_12 pixel_33 l1_msum_12 40697.674418604649
R_L1_m_34_12 pixel_34 l1_msum_12 137254.90196078431
R_L1_m_35_12 pixel_35 l1_msum_12 1000000
R_L1_m_36_12 pixel_36 l1_msum_12 34146.341463414632
R_L1_m_37_12 pixel_37 l1_msum_12 59829.059829059821
R_L1_m_38_12 pixel_38 l1_msum_12 46666.666666666664
R_L1_m_39_12 pixel_39 l1_msum_12 1000000
R_L1_m_40_12 pixel_40 l1_msum_12 1000000
R_L1_m_41_12 pixel_41 l1_msum_12 1000000
R_L1_m_42_12 pixel_42 l1_msum_12 54687.499999999993
R_L1_m_43_12 pixel_43 l1_msum_12 1000000
R_L1_m_44_12 pixel_44 l1_msum_12 1000000
R_L1_m_45_12 pixel_45 l1_msum_12 1000000
R_L1_m_46_12 pixel_46 l1_msum_12 1000000
R_L1_m_47_12 pixel_47 l1_msum_12 1000000
R_L1_m_48_12 pixel_48 l1_msum_12 1000000
R_L1_m_49_12 pixel_49 l1_msum_12 1000000
R_L1_m_50_12 pixel_50 l1_msum_12 1000000
R_L1_m_51_12 pixel_51 l1_msum_12 1000000
R_L1_m_52_12 pixel_52 l1_msum_12 1000000
R_L1_m_53_12 pixel_53 l1_msum_12 1000000
R_L1_m_54_12 pixel_54 l1_msum_12 1000000
R_L1_m_55_12 pixel_55 l1_msum_12 1000000
R_L1_m_56_12 pixel_56 l1_msum_12 388888.88888888888
R_L1_m_57_12 pixel_57 l1_msum_12 24822.695035460994
R_L1_m_58_12 pixel_58 l1_msum_12 50359.712230215831
R_L1_m_59_12 pixel_59 l1_msum_12 59829.059829059821
R_L1_m_60_12 pixel_60 l1_msum_12 83333.333333333328
R_L1_m_61_12 pixel_61 l1_msum_12 1000000
R_L1_m_62_12 pixel_62 l1_msum_12 66037.735849056597
R_L1_m_63_12 pixel_63 l1_msum_12 1000000
E_TIA_L1_m_12 l1_mout_12 0 0 l1_msum_12 100000000
R_FB_L1_m_12 l1_mout_12 l1_msum_12 1000
B_NEURON_L1_12 hidden_12 0 V={0.01*max(((V(l1_mout_12)-V(l1_pout_12))/0.0030903275574088963+(0.15764044225215912)),0)}
R_L1_p_0_13 pixel_0 l1_psum_13 1000000
R_L1_p_1_13 pixel_1 l1_psum_13 23890.784982935158
R_L1_p_2_13 pixel_2 l1_psum_13 25830.258302583028
R_L1_p_3_13 pixel_3 l1_psum_13 43478.260869565216
R_L1_p_4_13 pixel_4 l1_psum_13 83333.333333333328
R_L1_p_5_13 pixel_5 l1_psum_13 73684.210526315786
R_L1_p_6_13 pixel_6 l1_psum_13 112903.22580645159
R_L1_p_7_13 pixel_7 l1_psum_13 112903.22580645159
R_L1_p_8_13 pixel_8 l1_psum_13 1000000
R_L1_p_9_13 pixel_9 l1_psum_13 137254.90196078431
R_L1_p_10_13 pixel_10 l1_psum_13 1000000
R_L1_p_11_13 pixel_11 l1_psum_13 1000000
R_L1_p_12_13 pixel_12 l1_psum_13 1000000
R_L1_p_13_13 pixel_13 l1_psum_13 1000000
R_L1_p_14_13 pixel_14 l1_psum_13 1000000
R_L1_p_15_13 pixel_15 l1_psum_13 1000000
R_L1_p_16_13 pixel_16 l1_psum_13 73684.210526315786
R_L1_p_17_13 pixel_17 l1_psum_13 73684.210526315786
R_L1_p_18_13 pixel_18 l1_psum_13 1000000
R_L1_p_19_13 pixel_19 l1_psum_13 241379.31034482759
R_L1_p_20_13 pixel_20 l1_psum_13 1000000
R_L1_p_21_13 pixel_21 l1_psum_13 1000000
R_L1_p_22_13 pixel_22 l1_psum_13 1000000
R_L1_p_23_13 pixel_23 l1_psum_13 1000000
R_L1_p_24_13 pixel_24 l1_psum_13 1000000
R_L1_p_25_13 pixel_25 l1_psum_13 1000000
R_L1_p_26_13 pixel_26 l1_psum_13 1000000
R_L1_p_27_13 pixel_27 l1_psum_13 1000000
R_L1_p_28_13 pixel_28 l1_psum_13 1000000
R_L1_p_29_13 pixel_29 l1_psum_13 241379.31034482759
R_L1_p_30_13 pixel_30 l1_psum_13 1000000
R_L1_p_31_13 pixel_31 l1_psum_13 1000000
R_L1_p_32_13 pixel_32 l1_psum_13 66037.735849056597
R_L1_p_33_13 pixel_33 l1_psum_13 54687.499999999993
R_L1_p_34_13 pixel_34 l1_psum_13 32407.407407407409
R_L1_p_35_13 pixel_35 l1_psum_13 43478.260869565216
R_L1_p_36_13 pixel_36 l1_psum_13 40697.674418604649
R_L1_p_37_13 pixel_37 l1_psum_13 34146.341463414632
R_L1_p_38_13 pixel_38 l1_psum_13 66037.735849056597
R_L1_p_39_13 pixel_39 l1_psum_13 34146.341463414632
R_L1_p_40_13 pixel_40 l1_psum_13 28112.449799196787
R_L1_p_41_13 pixel_41 l1_psum_13 1000000
R_L1_p_42_13 pixel_42 l1_psum_13 112903.22580645159
R_L1_p_43_13 pixel_43 l1_psum_13 1000000
R_L1_p_44_13 pixel_44 l1_psum_13 112903.22580645159
R_L1_p_45_13 pixel_45 l1_psum_13 137254.90196078431
R_L1_p_46_13 pixel_46 l1_psum_13 388888.88888888888
R_L1_p_47_13 pixel_47 l1_psum_13 40697.674418604649
R_L1_p_48_13 pixel_48 l1_psum_13 137254.90196078431
R_L1_p_49_13 pixel_49 l1_psum_13 1000000
R_L1_p_50_13 pixel_50 l1_psum_13 1000000
R_L1_p_51_13 pixel_51 l1_psum_13 1000000
R_L1_p_52_13 pixel_52 l1_psum_13 1000000
R_L1_p_53_13 pixel_53 l1_psum_13 1000000
R_L1_p_54_13 pixel_54 l1_psum_13 1000000
R_L1_p_55_13 pixel_55 l1_psum_13 1000000
R_L1_p_56_13 pixel_56 l1_psum_13 175000.00000000003
R_L1_p_57_13 pixel_57 l1_psum_13 17369.727047146403
R_L1_p_58_13 pixel_58 l1_psum_13 59829.059829059821
R_L1_p_59_13 pixel_59 l1_psum_13 66037.735849056597
R_L1_p_60_13 pixel_60 l1_psum_13 34146.341463414632
R_L1_p_61_13 pixel_61 l1_psum_13 36082.474226804123
R_L1_p_62_13 pixel_62 l1_psum_13 46666.666666666664
R_L1_p_63_13 pixel_63 l1_psum_13 66037.735849056597
E_TIA_L1_p_13 l1_pout_13 0 0 l1_psum_13 100000000
R_FB_L1_p_13 l1_pout_13 l1_psum_13 1000
R_L1_m_0_13 pixel_0 l1_msum_13 59829.059829059821
R_L1_m_1_13 pixel_1 l1_msum_13 1000000
R_L1_m_2_13 pixel_2 l1_msum_13 1000000
R_L1_m_3_13 pixel_3 l1_msum_13 1000000
R_L1_m_4_13 pixel_4 l1_msum_13 1000000
R_L1_m_5_13 pixel_5 l1_msum_13 1000000
R_L1_m_6_13 pixel_6 l1_msum_13 1000000
R_L1_m_7_13 pixel_7 l1_msum_13 1000000
R_L1_m_8_13 pixel_8 l1_msum_13 54687.499999999993
R_L1_m_9_13 pixel_9 l1_msum_13 1000000
R_L1_m_10_13 pixel_10 l1_msum_13 241379.31034482759
R_L1_m_11_13 pixel_11 l1_msum_13 34146.341463414632
R_L1_m_12_13 pixel_12 l1_msum_13 83333.333333333328
R_L1_m_13_13 pixel_13 l1_msum_13 1000000
R_L1_m_14_13 pixel_14 l1_msum_13 175000.00000000003
R_L1_m_15_13 pixel_15 l1_msum_13 1000000
R_L1_m_16_13 pixel_16 l1_msum_13 1000000
R_L1_m_17_13 pixel_17 l1_msum_13 1000000
R_L1_m_18_13 pixel_18 l1_msum_13 241379.31034482759
R_L1_m_19_13 pixel_19 l1_msum_13 1000000
R_L1_m_20_13 pixel_20 l1_msum_13 73684.210526315786
R_L1_m_21_13 pixel_21 l1_msum_13 175000.00000000003
R_L1_m_22_13 pixel_22 l1_msum_13 95890.410958904104
R_L1_m_23_13 pixel_23 l1_msum_13 43478.260869565216
R_L1_m_24_13 pixel_24 l1_msum_13 28112.449799196787
R_L1_m_25_13 pixel_25 l1_msum_13 46666.666666666664
R_L1_m_26_13 pixel_26 l1_msum_13 59829.059829059821
R_L1_m_27_13 pixel_27 l1_msum_13 137254.90196078431
R_L1_m_28_13 pixel_28 l1_msum_13 175000.00000000003
R_L1_m_29_13 pixel_29 l1_msum_13 1000000
R_L1_m_30_13 pixel_30 l1_msum_13 34146.341463414632
R_L1_m_31_13 pixel_31 l1_msum_13 34146.341463414632
R_L1_m_32_13 pixel_32 l1_msum_13 1000000
R_L1_m_33_13 pixel_33 l1_msum_13 1000000
R_L1_m_34_13 pixel_34 l1_msum_13 1000000
R_L1_m_35_13 pixel_35 l1_msum_13 1000000
R_L1_m_36_13 pixel_36 l1_msum_13 1000000
R_L1_m_37_13 pixel_37 l1_msum_13 1000000
R_L1_m_38_13 pixel_38 l1_msum_13 1000000
R_L1_m_39_13 pixel_39 l1_msum_13 1000000
R_L1_m_40_13 pixel_40 l1_msum_13 1000000
R_L1_m_41_13 pixel_41 l1_msum_13 95890.410958904104
R_L1_m_42_13 pixel_42 l1_msum_13 1000000
R_L1_m_43_13 pixel_43 l1_msum_13 137254.90196078431
R_L1_m_44_13 pixel_44 l1_msum_13 1000000
R_L1_m_45_13 pixel_45 l1_msum_13 1000000
R_L1_m_46_13 pixel_46 l1_msum_13 1000000
R_L1_m_47_13 pixel_47 l1_msum_13 1000000
R_L1_m_48_13 pixel_48 l1_msum_13 1000000
R_L1_m_49_13 pixel_49 l1_msum_13 95890.410958904104
R_L1_m_50_13 pixel_50 l1_msum_13 34146.341463414632
R_L1_m_51_13 pixel_51 l1_msum_13 112903.22580645159
R_L1_m_52_13 pixel_52 l1_msum_13 50359.712230215831
R_L1_m_53_13 pixel_53 l1_msum_13 59829.059829059821
R_L1_m_54_13 pixel_54 l1_msum_13 59829.059829059821
R_L1_m_55_13 pixel_55 l1_msum_13 112903.22580645159
R_L1_m_56_13 pixel_56 l1_msum_13 1000000
R_L1_m_57_13 pixel_57 l1_msum_13 1000000
R_L1_m_58_13 pixel_58 l1_msum_13 1000000
R_L1_m_59_13 pixel_59 l1_msum_13 1000000
R_L1_m_60_13 pixel_60 l1_msum_13 1000000
R_L1_m_61_13 pixel_61 l1_msum_13 1000000
R_L1_m_62_13 pixel_62 l1_msum_13 1000000
R_L1_m_63_13 pixel_63 l1_msum_13 1000000
E_TIA_L1_m_13 l1_mout_13 0 0 l1_msum_13 100000000
R_FB_L1_m_13 l1_mout_13 l1_msum_13 1000
B_NEURON_L1_13 hidden_13 0 V={0.01*max(((V(l1_mout_13)-V(l1_pout_13))/0.0030903275574088963+(0.24066632986068726)),0)}
R_L1_p_0_14 pixel_0 l1_psum_14 1000000
R_L1_p_1_14 pixel_1 l1_psum_14 112903.22580645159
R_L1_p_2_14 pixel_2 l1_psum_14 1000000
R_L1_p_3_14 pixel_3 l1_psum_14 1000000
R_L1_p_4_14 pixel_4 l1_psum_14 1000000
R_L1_p_5_14 pixel_5 l1_psum_14 175000.00000000003
R_L1_p_6_14 pixel_6 l1_psum_14 1000000
R_L1_p_7_14 pixel_7 l1_psum_14 1000000
R_L1_p_8_14 pixel_8 l1_psum_14 73684.210526315786
R_L1_p_9_14 pixel_9 l1_psum_14 112903.22580645159
R_L1_p_10_14 pixel_10 l1_psum_14 241379.31034482759
R_L1_p_11_14 pixel_11 l1_psum_14 137254.90196078431
R_L1_p_12_14 pixel_12 l1_psum_14 112903.22580645159
R_L1_p_13_14 pixel_13 l1_psum_14 241379.31034482759
R_L1_p_14_14 pixel_14 l1_psum_14 1000000
R_L1_p_15_14 pixel_15 l1_psum_14 112903.22580645159
R_L1_p_16_14 pixel_16 l1_psum_14 1000000
R_L1_p_17_14 pixel_17 l1_psum_14 1000000
R_L1_p_18_14 pixel_18 l1_psum_14 59829.059829059821
R_L1_p_19_14 pixel_19 l1_psum_14 1000000
R_L1_p_20_14 pixel_20 l1_psum_14 1000000
R_L1_p_21_14 pixel_21 l1_psum_14 388888.88888888888
R_L1_p_22_14 pixel_22 l1_psum_14 112903.22580645159
R_L1_p_23_14 pixel_23 l1_psum_14 83333.333333333328
R_L1_p_24_14 pixel_24 l1_psum_14 1000000
R_L1_p_25_14 pixel_25 l1_psum_14 46666.666666666664
R_L1_p_26_14 pixel_26 l1_psum_14 59829.059829059821
R_L1_p_27_14 pixel_27 l1_psum_14 66037.735849056597
R_L1_p_28_14 pixel_28 l1_psum_14 95890.410958904104
R_L1_p_29_14 pixel_29 l1_psum_14 1000000
R_L1_p_30_14 pixel_30 l1_psum_14 73684.210526315786
R_L1_p_31_14 pixel_31 l1_psum_14 1000000
R_L1_p_32_14 pixel_32 l1_psum_14 1000000
R_L1_p_33_14 pixel_33 l1_psum_14 1000000
R_L1_p_34_14 pixel_34 l1_psum_14 1000000
R_L1_p_35_14 pixel_35 l1_psum_14 30837.004405286345
R_L1_p_36_14 pixel_36 l1_psum_14 54687.499999999993
R_L1_p_37_14 pixel_37 l1_psum_14 1000000
R_L1_p_38_14 pixel_38 l1_psum_14 1000000
R_L1_p_39_14 pixel_39 l1_psum_14 1000000
R_L1_p_40_14 pixel_40 l1_psum_14 59829.059829059821
R_L1_p_41_14 pixel_41 l1_psum_14 1000000
R_L1_p_42_14 pixel_42 l1_psum_14 1000000
R_L1_p_43_14 pixel_43 l1_psum_14 1000000
R_L1_p_44_14 pixel_44 l1_psum_14 1000000
R_L1_p_45_14 pixel_45 l1_psum_14 137254.90196078431
R_L1_p_46_14 pixel_46 l1_psum_14 1000000
R_L1_p_47_14 pixel_47 l1_psum_14 1000000
R_L1_p_48_14 pixel_48 l1_psum_14 30837.004405286345
R_L1_p_49_14 pixel_49 l1_psum_14 28112.449799196787
R_L1_p_50_14 pixel_50 l1_psum_14 36082.474226804123
R_L1_p_51_14 pixel_51 l1_psum_14 38251.366120218576
R_L1_p_52_14 pixel_52 l1_psum_14 241379.31034482759
R_L1_p_53_14 pixel_53 l1_psum_14 1000000
R_L1_p_54_14 pixel_54 l1_psum_14 1000000
R_L1_p_55_14 pixel_55 l1_psum_14 1000000
R_L1_p_56_14 pixel_56 l1_psum_14 1000000
R_L1_p_57_14 pixel_57 l1_psum_14 34146.341463414632
R_L1_p_58_14 pixel_58 l1_psum_14 40697.674418604649
R_L1_p_59_14 pixel_59 l1_psum_14 83333.333333333328
R_L1_p_60_14 pixel_60 l1_psum_14 95890.410958904104
R_L1_p_61_14 pixel_61 l1_psum_14 1000000
R_L1_p_62_14 pixel_62 l1_psum_14 59829.059829059821
R_L1_p_63_14 pixel_63 l1_psum_14 388888.88888888888
E_TIA_L1_p_14 l1_pout_14 0 0 l1_psum_14 100000000
R_FB_L1_p_14 l1_pout_14 l1_psum_14 1000
R_L1_m_0_14 pixel_0 l1_msum_14 1000000
R_L1_m_1_14 pixel_1 l1_msum_14 1000000
R_L1_m_2_14 pixel_2 l1_msum_14 46666.666666666664
R_L1_m_3_14 pixel_3 l1_msum_14 59829.059829059821
R_L1_m_4_14 pixel_4 l1_msum_14 32407.407407407409
R_L1_m_5_14 pixel_5 l1_msum_14 1000000
R_L1_m_6_14 pixel_6 l1_msum_14 46666.666666666664
R_L1_m_7_14 pixel_7 l1_msum_14 66037.735849056597
R_L1_m_8_14 pixel_8 l1_msum_14 1000000
R_L1_m_9_14 pixel_9 l1_msum_14 1000000
R_L1_m_10_14 pixel_10 l1_msum_14 1000000
R_L1_m_11_14 pixel_11 l1_msum_14 1000000
R_L1_m_12_14 pixel_12 l1_msum_14 1000000
R_L1_m_13_14 pixel_13 l1_msum_14 1000000
R_L1_m_14_14 pixel_14 l1_msum_14 59829.059829059821
R_L1_m_15_14 pixel_15 l1_msum_14 1000000
R_L1_m_16_14 pixel_16 l1_msum_14 388888.88888888888
R_L1_m_17_14 pixel_17 l1_msum_14 1000000
R_L1_m_18_14 pixel_18 l1_msum_14 1000000
R_L1_m_19_14 pixel_19 l1_msum_14 112903.22580645159
R_L1_m_20_14 pixel_20 l1_msum_14 137254.90196078431
R_L1_m_21_14 pixel_21 l1_msum_14 1000000
R_L1_m_22_14 pixel_22 l1_msum_14 1000000
R_L1_m_23_14 pixel_23 l1_msum_14 1000000
R_L1_m_24_14 pixel_24 l1_msum_14 43478.260869565216
R_L1_m_25_14 pixel_25 l1_msum_14 1000000
R_L1_m_26_14 pixel_26 l1_msum_14 1000000
R_L1_m_27_14 pixel_27 l1_msum_14 1000000
R_L1_m_28_14 pixel_28 l1_msum_14 1000000
R_L1_m_29_14 pixel_29 l1_msum_14 1000000
R_L1_m_30_14 pixel_30 l1_msum_14 1000000
R_L1_m_31_14 pixel_31 l1_msum_14 43478.260869565216
R_L1_m_32_14 pixel_32 l1_msum_14 46666.666666666664
R_L1_m_33_14 pixel_33 l1_msum_14 26923.076923076922
R_L1_m_34_14 pixel_34 l1_msum_14 40697.674418604649
R_L1_m_35_14 pixel_35 l1_msum_14 1000000
R_L1_m_36_14 pixel_36 l1_msum_14 1000000
R_L1_m_37_14 pixel_37 l1_msum_14 175000.00000000003
R_L1_m_38_14 pixel_38 l1_msum_14 95890.410958904104
R_L1_m_39_14 pixel_39 l1_msum_14 19498.607242339833
R_L1_m_40_14 pixel_40 l1_msum_14 1000000
R_L1_m_41_14 pixel_41 l1_msum_14 34146.341463414632
R_L1_m_42_14 pixel_42 l1_msum_14 15659.955257270693
R_L1_m_43_14 pixel_43 l1_msum_14 16908.212560386473
R_L1_m_44_14 pixel_44 l1_msum_14 50359.712230215831
R_L1_m_45_14 pixel_45 l1_msum_14 1000000
R_L1_m_46_14 pixel_46 l1_msum_14 66037.735849056597
R_L1_m_47_14 pixel_47 l1_msum_14 38251.366120218576
R_L1_m_48_14 pixel_48 l1_msum_14 1000000
R_L1_m_49_14 pixel_49 l1_msum_14 1000000
R_L1_m_50_14 pixel_50 l1_msum_14 1000000
R_L1_m_51_14 pixel_51 l1_msum_14 1000000
R_L1_m_52_14 pixel_52 l1_msum_14 1000000
R_L1_m_53_14 pixel_53 l1_msum_14 388888.88888888888
R_L1_m_54_14 pixel_54 l1_msum_14 43478.260869565216
R_L1_m_55_14 pixel_55 l1_msum_14 38251.366120218576
R_L1_m_56_14 pixel_56 l1_msum_14 241379.31034482759
R_L1_m_57_14 pixel_57 l1_msum_14 1000000
R_L1_m_58_14 pixel_58 l1_msum_14 1000000
R_L1_m_59_14 pixel_59 l1_msum_14 1000000
R_L1_m_60_14 pixel_60 l1_msum_14 1000000
R_L1_m_61_14 pixel_61 l1_msum_14 95890.410958904104
R_L1_m_62_14 pixel_62 l1_msum_14 1000000
R_L1_m_63_14 pixel_63 l1_msum_14 1000000
E_TIA_L1_m_14 l1_mout_14 0 0 l1_msum_14 100000000
R_FB_L1_m_14 l1_mout_14 l1_msum_14 1000
B_NEURON_L1_14 hidden_14 0 V={0.01*max(((V(l1_mout_14)-V(l1_pout_14))/0.0030903275574088963+(-0.17192971706390381)),0)}
R_L1_p_0_15 pixel_0 l1_psum_15 29411.764705882353
R_L1_p_1_15 pixel_1 l1_psum_15 26923.076923076922
R_L1_p_2_15 pixel_2 l1_psum_15 16055.045871559634
R_L1_p_3_15 pixel_3 l1_psum_15 13358.778625954199
R_L1_p_4_15 pixel_4 l1_psum_15 26923.076923076922
R_L1_p_5_15 pixel_5 l1_psum_15 46666.666666666664
R_L1_p_6_15 pixel_6 l1_psum_15 388888.88888888888
R_L1_p_7_15 pixel_7 l1_psum_15 1000000
R_L1_p_8_15 pixel_8 l1_psum_15 175000.00000000003
R_L1_p_9_15 pixel_9 l1_psum_15 241379.31034482759
R_L1_p_10_15 pixel_10 l1_psum_15 1000000
R_L1_p_11_15 pixel_11 l1_psum_15 1000000
R_L1_p_12_15 pixel_12 l1_psum_15 388888.88888888888
R_L1_p_13_15 pixel_13 l1_psum_15 95890.410958904104
R_L1_p_14_15 pixel_14 l1_psum_15 1000000
R_L1_p_15_15 pixel_15 l1_psum_15 1000000
R_L1_p_16_15 pixel_16 l1_psum_15 54687.499999999993
R_L1_p_17_15 pixel_17 l1_psum_15 43478.260869565216
R_L1_p_18_15 pixel_18 l1_psum_15 1000000
R_L1_p_19_15 pixel_19 l1_psum_15 1000000
R_L1_p_20_15 pixel_20 l1_psum_15 95890.410958904104
R_L1_p_21_15 pixel_21 l1_psum_15 73684.210526315786
R_L1_p_22_15 pixel_22 l1_psum_15 40697.674418604649
R_L1_p_23_15 pixel_23 l1_psum_15 1000000
R_L1_p_24_15 pixel_24 l1_psum_15 175000.00000000003
R_L1_p_25_15 pixel_25 l1_psum_15 59829.059829059821
R_L1_p_26_15 pixel_26 l1_psum_15 1000000
R_L1_p_27_15 pixel_27 l1_psum_15 1000000
R_L1_p_28_15 pixel_28 l1_psum_15 59829.059829059821
R_L1_p_29_15 pixel_29 l1_psum_15 1000000
R_L1_p_30_15 pixel_30 l1_psum_15 25830.258302583028
R_L1_p_31_15 pixel_31 l1_psum_15 46666.666666666664
R_L1_p_32_15 pixel_32 l1_psum_15 1000000
R_L1_p_33_15 pixel_33 l1_psum_15 1000000
R_L1_p_34_15 pixel_34 l1_psum_15 388888.88888888888
R_L1_p_35_15 pixel_35 l1_psum_15 59829.059829059821
R_L1_p_36_15 pixel_36 l1_psum_15 1000000
R_L1_p_37_15 pixel_37 l1_psum_15 1000000
R_L1_p_38_15 pixel_38 l1_psum_15 59829.059829059821
R_L1_p_39_15 pixel_39 l1_psum_15 29411.764705882353
R_L1_p_40_15 pixel_40 l1_psum_15 1000000
R_L1_p_41_15 pixel_41 l1_psum_15 1000000
R_L1_p_42_15 pixel_42 l1_psum_15 73684.210526315786
R_L1_p_43_15 pixel_43 l1_psum_15 73684.210526315786
R_L1_p_44_15 pixel_44 l1_psum_15 1000000
R_L1_p_45_15 pixel_45 l1_psum_15 137254.90196078431
R_L1_p_46_15 pixel_46 l1_psum_15 175000.00000000003
R_L1_p_47_15 pixel_47 l1_psum_15 50359.712230215831
R_L1_p_48_15 pixel_48 l1_psum_15 1000000
R_L1_p_49_15 pixel_49 l1_psum_15 38251.366120218576
R_L1_p_50_15 pixel_50 l1_psum_15 59829.059829059821
R_L1_p_51_15 pixel_51 l1_psum_15 175000.00000000003
R_L1_p_52_15 pixel_52 l1_psum_15 388888.88888888888
R_L1_p_53_15 pixel_53 l1_psum_15 1000000
R_L1_p_54_15 pixel_54 l1_psum_15 1000000
R_L1_p_55_15 pixel_55 l1_psum_15 1000000
R_L1_p_56_15 pixel_56 l1_psum_15 1000000
R_L1_p_57_15 pixel_57 l1_psum_15 1000000
R_L1_p_58_15 pixel_58 l1_psum_15 1000000
R_L1_p_59_15 pixel_59 l1_psum_15 388888.88888888888
R_L1_p_60_15 pixel_60 l1_psum_15 1000000
R_L1_p_61_15 pixel_61 l1_psum_15 1000000
R_L1_p_62_15 pixel_62 l1_psum_15 1000000
R_L1_p_63_15 pixel_63 l1_psum_15 1000000
E_TIA_L1_p_15 l1_pout_15 0 0 l1_psum_15 100000000
R_FB_L1_p_15 l1_pout_15 l1_psum_15 1000
R_L1_m_0_15 pixel_0 l1_msum_15 1000000
R_L1_m_1_15 pixel_1 l1_msum_15 1000000
R_L1_m_2_15 pixel_2 l1_msum_15 1000000
R_L1_m_3_15 pixel_3 l1_msum_15 1000000
R_L1_m_4_15 pixel_4 l1_msum_15 1000000
R_L1_m_5_15 pixel_5 l1_msum_15 1000000
R_L1_m_6_15 pixel_6 l1_msum_15 1000000
R_L1_m_7_15 pixel_7 l1_msum_15 241379.31034482759
R_L1_m_8_15 pixel_8 l1_msum_15 1000000
R_L1_m_9_15 pixel_9 l1_msum_15 1000000
R_L1_m_10_15 pixel_10 l1_msum_15 241379.31034482759
R_L1_m_11_15 pixel_11 l1_msum_15 241379.31034482759
R_L1_m_12_15 pixel_12 l1_msum_15 1000000
R_L1_m_13_15 pixel_13 l1_msum_15 1000000
R_L1_m_14_15 pixel_14 l1_msum_15 95890.410958904104
R_L1_m_15_15 pixel_15 l1_msum_15 83333.333333333328
R_L1_m_16_15 pixel_16 l1_msum_15 1000000
R_L1_m_17_15 pixel_17 l1_msum_15 1000000
R_L1_m_18_15 pixel_18 l1_msum_15 137254.90196078431
R_L1_m_19_15 pixel_19 l1_msum_15 83333.333333333328
R_L1_m_20_15 pixel_20 l1_msum_15 1000000
R_L1_m_21_15 pixel_21 l1_msum_15 1000000
R_L1_m_22_15 pixel_22 l1_msum_15 1000000
R_L1_m_23_15 pixel_23 l1_msum_15 50359.712230215831
R_L1_m_24_15 pixel_24 l1_msum_15 1000000
R_L1_m_25_15 pixel_25 l1_msum_15 1000000
R_L1_m_26_15 pixel_26 l1_msum_15 137254.90196078431
R_L1_m_27_15 pixel_27 l1_msum_15 241379.31034482759
R_L1_m_28_15 pixel_28 l1_msum_15 1000000
R_L1_m_29_15 pixel_29 l1_msum_15 1000000
R_L1_m_30_15 pixel_30 l1_msum_15 1000000
R_L1_m_31_15 pixel_31 l1_msum_15 1000000
R_L1_m_32_15 pixel_32 l1_msum_15 54687.499999999993
R_L1_m_33_15 pixel_33 l1_msum_15 1000000
R_L1_m_34_15 pixel_34 l1_msum_15 1000000
R_L1_m_35_15 pixel_35 l1_msum_15 1000000
R_L1_m_36_15 pixel_36 l1_msum_15 175000.00000000003
R_L1_m_37_15 pixel_37 l1_msum_15 38251.366120218576
R_L1_m_38_15 pixel_38 l1_msum_15 1000000
R_L1_m_39_15 pixel_39 l1_msum_15 1000000
R_L1_m_40_15 pixel_40 l1_msum_15 38251.366120218576
R_L1_m_41_15 pixel_41 l1_msum_15 112903.22580645159
R_L1_m_42_15 pixel_42 l1_msum_15 1000000
R_L1_m_43_15 pixel_43 l1_msum_15 1000000
R_L1_m_44_15 pixel_44 l1_msum_15 241379.31034482759
R_L1_m_45_15 pixel_45 l1_msum_15 1000000
R_L1_m_46_15 pixel_46 l1_msum_15 1000000
R_L1_m_47_15 pixel_47 l1_msum_15 1000000
R_L1_m_48_15 pixel_48 l1_msum_15 54687.499999999993
R_L1_m_49_15 pixel_49 l1_msum_15 1000000
R_L1_m_50_15 pixel_50 l1_msum_15 1000000
R_L1_m_51_15 pixel_51 l1_msum_15 1000000
R_L1_m_52_15 pixel_52 l1_msum_15 1000000
R_L1_m_53_15 pixel_53 l1_msum_15 66037.735849056597
R_L1_m_54_15 pixel_54 l1_msum_15 28112.449799196787
R_L1_m_55_15 pixel_55 l1_msum_15 73684.210526315786
R_L1_m_56_15 pixel_56 l1_msum_15 46666.666666666664
R_L1_m_57_15 pixel_57 l1_msum_15 137254.90196078431
R_L1_m_58_15 pixel_58 l1_msum_15 241379.31034482759
R_L1_m_59_15 pixel_59 l1_msum_15 1000000
R_L1_m_60_15 pixel_60 l1_msum_15 59829.059829059821
R_L1_m_61_15 pixel_61 l1_msum_15 83333.333333333328
R_L1_m_62_15 pixel_62 l1_msum_15 83333.333333333328
R_L1_m_63_15 pixel_63 l1_msum_15 175000.00000000003
E_TIA_L1_m_15 l1_mout_15 0 0 l1_msum_15 100000000
R_FB_L1_m_15 l1_mout_15 l1_msum_15 1000
B_NEURON_L1_15 hidden_15 0 V={0.01*max(((V(l1_mout_15)-V(l1_pout_15))/0.0030903275574088963+(0.16574917733669281)),0)}
R_L1_p_0_16 pixel_0 l1_psum_16 1000000
R_L1_p_1_16 pixel_1 l1_psum_16 1000000
R_L1_p_2_16 pixel_2 l1_psum_16 1000000
R_L1_p_3_16 pixel_3 l1_psum_16 1000000
R_L1_p_4_16 pixel_4 l1_psum_16 1000000
R_L1_p_5_16 pixel_5 l1_psum_16 1000000
R_L1_p_6_16 pixel_6 l1_psum_16 1000000
R_L1_p_7_16 pixel_7 l1_psum_16 83333.333333333328
R_L1_p_8_16 pixel_8 l1_psum_16 1000000
R_L1_p_9_16 pixel_9 l1_psum_16 1000000
R_L1_p_10_16 pixel_10 l1_psum_16 1000000
R_L1_p_11_16 pixel_11 l1_psum_16 73684.210526315786
R_L1_p_12_16 pixel_12 l1_psum_16 66037.735849056597
R_L1_p_13_16 pixel_13 l1_psum_16 73684.210526315786
R_L1_p_14_16 pixel_14 l1_psum_16 1000000
R_L1_p_15_16 pixel_15 l1_psum_16 73684.210526315786
R_L1_p_16_16 pixel_16 l1_psum_16 1000000
R_L1_p_17_16 pixel_17 l1_psum_16 1000000
R_L1_p_18_16 pixel_18 l1_psum_16 137254.90196078431
R_L1_p_19_16 pixel_19 l1_psum_16 241379.31034482759
R_L1_p_20_16 pixel_20 l1_psum_16 83333.333333333328
R_L1_p_21_16 pixel_21 l1_psum_16 73684.210526315786
R_L1_p_22_16 pixel_22 l1_psum_16 73684.210526315786
R_L1_p_23_16 pixel_23 l1_psum_16 66037.735849056597
R_L1_p_24_16 pixel_24 l1_psum_16 66037.735849056597
R_L1_p_25_16 pixel_25 l1_psum_16 137254.90196078431
R_L1_p_26_16 pixel_26 l1_psum_16 1000000
R_L1_p_27_16 pixel_27 l1_psum_16 1000000
R_L1_p_28_16 pixel_28 l1_psum_16 1000000
R_L1_p_29_16 pixel_29 l1_psum_16 83333.333333333328
R_L1_p_30_16 pixel_30 l1_psum_16 1000000
R_L1_p_31_16 pixel_31 l1_psum_16 95890.410958904104
R_L1_p_32_16 pixel_32 l1_psum_16 59829.059829059821
R_L1_p_33_16 pixel_33 l1_psum_16 83333.333333333328
R_L1_p_34_16 pixel_34 l1_psum_16 36082.474226804123
R_L1_p_35_16 pixel_35 l1_psum_16 36082.474226804123
R_L1_p_36_16 pixel_36 l1_psum_16 50359.712230215831
R_L1_p_37_16 pixel_37 l1_psum_16 59829.059829059821
R_L1_p_38_16 pixel_38 l1_psum_16 1000000
R_L1_p_39_16 pixel_39 l1_psum_16 50359.712230215831
R_L1_p_40_16 pixel_40 l1_psum_16 112903.22580645159
R_L1_p_41_16 pixel_41 l1_psum_16 241379.31034482759
R_L1_p_42_16 pixel_42 l1_psum_16 59829.059829059821
R_L1_p_43_16 pixel_43 l1_psum_16 1000000
R_L1_p_44_16 pixel_44 l1_psum_16 1000000
R_L1_p_45_16 pixel_45 l1_psum_16 1000000
R_L1_p_46_16 pixel_46 l1_psum_16 66037.735849056597
R_L1_p_47_16 pixel_47 l1_psum_16 137254.90196078431
R_L1_p_48_16 pixel_48 l1_psum_16 50359.712230215831
R_L1_p_49_16 pixel_49 l1_psum_16 95890.410958904104
R_L1_p_50_16 pixel_50 l1_psum_16 175000.00000000003
R_L1_p_51_16 pixel_51 l1_psum_16 112903.22580645159
R_L1_p_52_16 pixel_52 l1_psum_16 1000000
R_L1_p_53_16 pixel_53 l1_psum_16 1000000
R_L1_p_54_16 pixel_54 l1_psum_16 40697.674418604649
R_L1_p_55_16 pixel_55 l1_psum_16 1000000
R_L1_p_56_16 pixel_56 l1_psum_16 1000000
R_L1_p_57_16 pixel_57 l1_psum_16 1000000
R_L1_p_58_16 pixel_58 l1_psum_16 1000000
R_L1_p_59_16 pixel_59 l1_psum_16 1000000
R_L1_p_60_16 pixel_60 l1_psum_16 112903.22580645159
R_L1_p_61_16 pixel_61 l1_psum_16 1000000
R_L1_p_62_16 pixel_62 l1_psum_16 1000000
R_L1_p_63_16 pixel_63 l1_psum_16 66037.735849056597
E_TIA_L1_p_16 l1_pout_16 0 0 l1_psum_16 100000000
R_FB_L1_p_16 l1_pout_16 l1_psum_16 1000
R_L1_m_0_16 pixel_0 l1_msum_16 73684.210526315786
R_L1_m_1_16 pixel_1 l1_msum_16 32407.407407407409
R_L1_m_2_16 pixel_2 l1_msum_16 29411.764705882353
R_L1_m_3_16 pixel_3 l1_msum_16 30837.004405286345
R_L1_m_4_16 pixel_4 l1_msum_16 50359.712230215831
R_L1_m_5_16 pixel_5 l1_msum_16 24822.695035460994
R_L1_m_6_16 pixel_6 l1_msum_16 43478.260869565216
R_L1_m_7_16 pixel_7 l1_msum_16 1000000
R_L1_m_8_16 pixel_8 l1_msum_16 38251.366120218576
R_L1_m_9_16 pixel_9 l1_msum_16 112903.22580645159
R_L1_m_10_16 pixel_10 l1_msum_16 388888.88888888888
R_L1_m_11_16 pixel_11 l1_msum_16 1000000
R_L1_m_12_16 pixel_12 l1_msum_16 1000000
R_L1_m_13_16 pixel_13 l1_msum_16 1000000
R_L1_m_14_16 pixel_14 l1_msum_16 73684.210526315786
R_L1_m_15_16 pixel_15 l1_msum_16 1000000
R_L1_m_16_16 pixel_16 l1_msum_16 241379.31034482759
R_L1_m_17_16 pixel_17 l1_msum_16 137254.90196078431
R_L1_m_18_16 pixel_18 l1_msum_16 1000000
R_L1_m_19_16 pixel_19 l1_msum_16 1000000
R_L1_m_20_16 pixel_20 l1_msum_16 1000000
R_L1_m_21_16 pixel_21 l1_msum_16 1000000
R_L1_m_22_16 pixel_22 l1_msum_16 1000000
R_L1_m_23_16 pixel_23 l1_msum_16 1000000
R_L1_m_24_16 pixel_24 l1_msum_16 1000000
R_L1_m_25_16 pixel_25 l1_msum_16 1000000
R_L1_m_26_16 pixel_26 l1_msum_16 175000.00000000003
R_L1_m_27_16 pixel_27 l1_msum_16 83333.333333333328
R_L1_m_28_16 pixel_28 l1_msum_16 26923.076923076922
R_L1_m_29_16 pixel_29 l1_msum_16 1000000
R_L1_m_30_16 pixel_30 l1_msum_16 241379.31034482759
R_L1_m_31_16 pixel_31 l1_msum_16 1000000
R_L1_m_32_16 pixel_32 l1_msum_16 1000000
R_L1_m_33_16 pixel_33 l1_msum_16 1000000
R_L1_m_34_16 pixel_34 l1_msum_16 1000000
R_L1_m_35_16 pixel_35 l1_msum_16 1000000
R_L1_m_36_16 pixel_36 l1_msum_16 1000000
R_L1_m_37_16 pixel_37 l1_msum_16 1000000
R_L1_m_38_16 pixel_38 l1_msum_16 112903.22580645159
R_L1_m_39_16 pixel_39 l1_msum_16 1000000
R_L1_m_40_16 pixel_40 l1_msum_16 1000000
R_L1_m_41_16 pixel_41 l1_msum_16 1000000
R_L1_m_42_16 pixel_42 l1_msum_16 1000000
R_L1_m_43_16 pixel_43 l1_msum_16 59829.059829059821
R_L1_m_44_16 pixel_44 l1_msum_16 95890.410958904104
R_L1_m_45_16 pixel_45 l1_msum_16 112903.22580645159
R_L1_m_46_16 pixel_46 l1_msum_16 1000000
R_L1_m_47_16 pixel_47 l1_msum_16 1000000
R_L1_m_48_16 pixel_48 l1_msum_16 1000000
R_L1_m_49_16 pixel_49 l1_msum_16 1000000
R_L1_m_50_16 pixel_50 l1_msum_16 1000000
R_L1_m_51_16 pixel_51 l1_msum_16 1000000
R_L1_m_52_16 pixel_52 l1_msum_16 54687.499999999993
R_L1_m_53_16 pixel_53 l1_msum_16 112903.22580645159
R_L1_m_54_16 pixel_54 l1_msum_16 1000000
R_L1_m_55_16 pixel_55 l1_msum_16 112903.22580645159
R_L1_m_56_16 pixel_56 l1_msum_16 38251.366120218576
R_L1_m_57_16 pixel_57 l1_msum_16 1000000
R_L1_m_58_16 pixel_58 l1_msum_16 73684.210526315786
R_L1_m_59_16 pixel_59 l1_msum_16 83333.333333333328
R_L1_m_60_16 pixel_60 l1_msum_16 1000000
R_L1_m_61_16 pixel_61 l1_msum_16 25830.258302583028
R_L1_m_62_16 pixel_62 l1_msum_16 36082.474226804123
R_L1_m_63_16 pixel_63 l1_msum_16 1000000
E_TIA_L1_m_16 l1_mout_16 0 0 l1_msum_16 100000000
R_FB_L1_m_16 l1_mout_16 l1_msum_16 1000
B_NEURON_L1_16 hidden_16 0 V={0.01*max(((V(l1_mout_16)-V(l1_pout_16))/0.0030903275574088963+(0.15818198025226593)),0)}
R_L1_p_0_17 pixel_0 l1_psum_17 1000000
R_L1_p_1_17 pixel_1 l1_psum_17 1000000
R_L1_p_2_17 pixel_2 l1_psum_17 1000000
R_L1_p_3_17 pixel_3 l1_psum_17 1000000
R_L1_p_4_17 pixel_4 l1_psum_17 29411.764705882353
R_L1_p_5_17 pixel_5 l1_psum_17 34146.341463414632
R_L1_p_6_17 pixel_6 l1_psum_17 175000.00000000003
R_L1_p_7_17 pixel_7 l1_psum_17 1000000
R_L1_p_8_17 pixel_8 l1_psum_17 175000.00000000003
R_L1_p_9_17 pixel_9 l1_psum_17 43478.260869565216
R_L1_p_10_17 pixel_10 l1_psum_17 1000000
R_L1_p_11_17 pixel_11 l1_psum_17 1000000
R_L1_p_12_17 pixel_12 l1_psum_17 40697.674418604649
R_L1_p_13_17 pixel_13 l1_psum_17 1000000
R_L1_p_14_17 pixel_14 l1_psum_17 1000000
R_L1_p_15_17 pixel_15 l1_psum_17 1000000
R_L1_p_16_17 pixel_16 l1_psum_17 175000.00000000003
R_L1_p_17_17 pixel_17 l1_psum_17 1000000
R_L1_p_18_17 pixel_18 l1_psum_17 1000000
R_L1_p_19_17 pixel_19 l1_psum_17 73684.210526315786
R_L1_p_20_17 pixel_20 l1_psum_17 66037.735849056597
R_L1_p_21_17 pixel_21 l1_psum_17 1000000
R_L1_p_22_17 pixel_22 l1_psum_17 1000000
R_L1_p_23_17 pixel_23 l1_psum_17 1000000
R_L1_p_24_17 pixel_24 l1_psum_17 83333.333333333328
R_L1_p_25_17 pixel_25 l1_psum_17 1000000
R_L1_p_26_17 pixel_26 l1_psum_17 137254.90196078431
R_L1_p_27_17 pixel_27 l1_psum_17 36082.474226804123
R_L1_p_28_17 pixel_28 l1_psum_17 1000000
R_L1_p_29_17 pixel_29 l1_psum_17 1000000
R_L1_p_30_17 pixel_30 l1_psum_17 1000000
R_L1_p_31_17 pixel_31 l1_psum_17 1000000
R_L1_p_32_17 pixel_32 l1_psum_17 1000000
R_L1_p_33_17 pixel_33 l1_psum_17 1000000
R_L1_p_34_17 pixel_34 l1_psum_17 54687.499999999993
R_L1_p_35_17 pixel_35 l1_psum_17 1000000
R_L1_p_36_17 pixel_36 l1_psum_17 1000000
R_L1_p_37_17 pixel_37 l1_psum_17 112903.22580645159
R_L1_p_38_17 pixel_38 l1_psum_17 43478.260869565216
R_L1_p_39_17 pixel_39 l1_psum_17 1000000
R_L1_p_40_17 pixel_40 l1_psum_17 1000000
R_L1_p_41_17 pixel_41 l1_psum_17 1000000
R_L1_p_42_17 pixel_42 l1_psum_17 1000000
R_L1_p_43_17 pixel_43 l1_psum_17 1000000
R_L1_p_44_17 pixel_44 l1_psum_17 66037.735849056597
R_L1_p_45_17 pixel_45 l1_psum_17 66037.735849056597
R_L1_p_46_17 pixel_46 l1_psum_17 46666.666666666664
R_L1_p_47_17 pixel_47 l1_psum_17 1000000
R_L1_p_48_17 pixel_48 l1_psum_17 1000000
R_L1_p_49_17 pixel_49 l1_psum_17 1000000
R_L1_p_50_17 pixel_50 l1_psum_17 1000000
R_L1_p_51_17 pixel_51 l1_psum_17 73684.210526315786
R_L1_p_52_17 pixel_52 l1_psum_17 137254.90196078431
R_L1_p_53_17 pixel_53 l1_psum_17 40697.674418604649
R_L1_p_54_17 pixel_54 l1_psum_17 59829.059829059821
R_L1_p_55_17 pixel_55 l1_psum_17 66037.735849056597
R_L1_p_56_17 pixel_56 l1_psum_17 1000000
R_L1_p_57_17 pixel_57 l1_psum_17 28112.449799196787
R_L1_p_58_17 pixel_58 l1_psum_17 73684.210526315786
R_L1_p_59_17 pixel_59 l1_psum_17 1000000
R_L1_p_60_17 pixel_60 l1_psum_17 1000000
R_L1_p_61_17 pixel_61 l1_psum_17 1000000
R_L1_p_62_17 pixel_62 l1_psum_17 112903.22580645159
R_L1_p_63_17 pixel_63 l1_psum_17 1000000
E_TIA_L1_p_17 l1_pout_17 0 0 l1_psum_17 100000000
R_FB_L1_p_17 l1_pout_17 l1_psum_17 1000
R_L1_m_0_17 pixel_0 l1_msum_17 1000000
R_L1_m_1_17 pixel_1 l1_msum_17 112903.22580645159
R_L1_m_2_17 pixel_2 l1_msum_17 16908.212560386473
R_L1_m_3_17 pixel_3 l1_msum_17 137254.90196078431
R_L1_m_4_17 pixel_4 l1_msum_17 1000000
R_L1_m_5_17 pixel_5 l1_msum_17 1000000
R_L1_m_6_17 pixel_6 l1_msum_17 1000000
R_L1_m_7_17 pixel_7 l1_msum_17 36082.474226804123
R_L1_m_8_17 pixel_8 l1_msum_17 1000000
R_L1_m_9_17 pixel_9 l1_msum_17 1000000
R_L1_m_10_17 pixel_10 l1_msum_17 34146.341463414632
R_L1_m_11_17 pixel_11 l1_msum_17 137254.90196078431
R_L1_m_12_17 pixel_12 l1_msum_17 1000000
R_L1_m_13_17 pixel_13 l1_msum_17 137254.90196078431
R_L1_m_14_17 pixel_14 l1_msum_17 30837.004405286345
R_L1_m_15_17 pixel_15 l1_msum_17 18372.70341207349
R_L1_m_16_17 pixel_16 l1_msum_17 1000000
R_L1_m_17_17 pixel_17 l1_msum_17 1000000
R_L1_m_18_17 pixel_18 l1_msum_17 16470.588235294119
R_L1_m_19_17 pixel_19 l1_msum_17 1000000
R_L1_m_20_17 pixel_20 l1_msum_17 1000000
R_L1_m_21_17 pixel_21 l1_msum_17 17857.142857142859
R_L1_m_22_17 pixel_22 l1_msum_17 34146.341463414632
R_L1_m_23_17 pixel_23 l1_msum_17 30837.004405286345
R_L1_m_24_17 pixel_24 l1_msum_17 1000000
R_L1_m_25_17 pixel_25 l1_msum_17 28112.449799196787
R_L1_m_26_17 pixel_26 l1_msum_17 1000000
R_L1_m_27_17 pixel_27 l1_msum_17 1000000
R_L1_m_28_17 pixel_28 l1_msum_17 36082.474226804123
R_L1_m_29_17 pixel_29 l1_msum_17 46666.666666666664
R_L1_m_30_17 pixel_30 l1_msum_17 28112.449799196787
R_L1_m_31_17 pixel_31 l1_msum_17 25830.258302583028
R_L1_m_32_17 pixel_32 l1_msum_17 112903.22580645159
R_L1_m_33_17 pixel_33 l1_msum_17 388888.88888888888
R_L1_m_34_17 pixel_34 l1_msum_17 1000000
R_L1_m_35_17 pixel_35 l1_msum_17 95890.410958904104
R_L1_m_36_17 pixel_36 l1_msum_17 73684.210526315786
R_L1_m_37_17 pixel_37 l1_msum_17 1000000
R_L1_m_38_17 pixel_38 l1_msum_17 1000000
R_L1_m_39_17 pixel_39 l1_msum_17 23026.315789473687
R_L1_m_40_17 pixel_40 l1_msum_17 73684.210526315786
R_L1_m_41_17 pixel_41 l1_msum_17 95890.410958904104
R_L1_m_42_17 pixel_42 l1_msum_17 388888.88888888888
R_L1_m_43_17 pixel_43 l1_msum_17 388888.88888888888
R_L1_m_44_17 pixel_44 l1_msum_17 1000000
R_L1_m_45_17 pixel_45 l1_msum_17 1000000
R_L1_m_46_17 pixel_46 l1_msum_17 1000000
R_L1_m_47_17 pixel_47 l1_msum_17 137254.90196078431
R_L1_m_48_17 pixel_48 l1_msum_17 50359.712230215831
R_L1_m_49_17 pixel_49 l1_msum_17 59829.059829059821
R_L1_m_50_17 pixel_50 l1_msum_17 388888.88888888888
R_L1_m_51_17 pixel_51 l1_msum_17 1000000
R_L1_m_52_17 pixel_52 l1_msum_17 1000000
R_L1_m_53_17 pixel_53 l1_msum_17 1000000
R_L1_m_54_17 pixel_54 l1_msum_17 1000000
R_L1_m_55_17 pixel_55 l1_msum_17 1000000
R_L1_m_56_17 pixel_56 l1_msum_17 112903.22580645159
R_L1_m_57_17 pixel_57 l1_msum_17 1000000
R_L1_m_58_17 pixel_58 l1_msum_17 1000000
R_L1_m_59_17 pixel_59 l1_msum_17 25830.258302583028
R_L1_m_60_17 pixel_60 l1_msum_17 16908.212560386473
R_L1_m_61_17 pixel_61 l1_msum_17 26923.076923076922
R_L1_m_62_17 pixel_62 l1_msum_17 1000000
R_L1_m_63_17 pixel_63 l1_msum_17 137254.90196078431
E_TIA_L1_m_17 l1_mout_17 0 0 l1_msum_17 100000000
R_FB_L1_m_17 l1_mout_17 l1_msum_17 1000
B_NEURON_L1_17 hidden_17 0 V={0.01*max(((V(l1_mout_17)-V(l1_pout_17))/0.0030903275574088963+(0.37551790475845337)),0)}
R_L1_p_0_18 pixel_0 l1_psum_18 1000000
R_L1_p_1_18 pixel_1 l1_psum_18 50359.712230215831
R_L1_p_2_18 pixel_2 l1_psum_18 1000000
R_L1_p_3_18 pixel_3 l1_psum_18 1000000
R_L1_p_4_18 pixel_4 l1_psum_18 1000000
R_L1_p_5_18 pixel_5 l1_psum_18 43478.260869565216
R_L1_p_6_18 pixel_6 l1_psum_18 23890.784982935158
R_L1_p_7_18 pixel_7 l1_psum_18 1000000
R_L1_p_8_18 pixel_8 l1_psum_18 137254.90196078431
R_L1_p_9_18 pixel_9 l1_psum_18 1000000
R_L1_p_10_18 pixel_10 l1_psum_18 137254.90196078431
R_L1_p_11_18 pixel_11 l1_psum_18 66037.735849056597
R_L1_p_12_18 pixel_12 l1_psum_18 137254.90196078431
R_L1_p_13_18 pixel_13 l1_psum_18 388888.88888888888
R_L1_p_14_18 pixel_14 l1_psum_18 95890.410958904104
R_L1_p_15_18 pixel_15 l1_psum_18 22222.222222222223
R_L1_p_16_18 pixel_16 l1_psum_18 1000000
R_L1_p_17_18 pixel_17 l1_psum_18 73684.210526315786
R_L1_p_18_18 pixel_18 l1_psum_18 36082.474226804123
R_L1_p_19_18 pixel_19 l1_psum_18 73684.210526315786
R_L1_p_20_18 pixel_20 l1_psum_18 1000000
R_L1_p_21_18 pixel_21 l1_psum_18 1000000
R_L1_p_22_18 pixel_22 l1_psum_18 1000000
R_L1_p_23_18 pixel_23 l1_psum_18 59829.059829059821
R_L1_p_24_18 pixel_24 l1_psum_18 112903.22580645159
R_L1_p_25_18 pixel_25 l1_psum_18 66037.735849056597
R_L1_p_26_18 pixel_26 l1_psum_18 54687.499999999993
R_L1_p_27_18 pixel_27 l1_psum_18 112903.22580645159
R_L1_p_28_18 pixel_28 l1_psum_18 40697.674418604649
R_L1_p_29_18 pixel_29 l1_psum_18 95890.410958904104
R_L1_p_30_18 pixel_30 l1_psum_18 1000000
R_L1_p_31_18 pixel_31 l1_psum_18 1000000
R_L1_p_32_18 pixel_32 l1_psum_18 1000000
R_L1_p_33_18 pixel_33 l1_psum_18 1000000
R_L1_p_34_18 pixel_34 l1_psum_18 175000.00000000003
R_L1_p_35_18 pixel_35 l1_psum_18 50359.712230215831
R_L1_p_36_18 pixel_36 l1_psum_18 32407.407407407409
R_L1_p_37_18 pixel_37 l1_psum_18 66037.735849056597
R_L1_p_38_18 pixel_38 l1_psum_18 1000000
R_L1_p_39_18 pixel_39 l1_psum_18 1000000
R_L1_p_40_18 pixel_40 l1_psum_18 1000000
R_L1_p_41_18 pixel_41 l1_psum_18 1000000
R_L1_p_42_18 pixel_42 l1_psum_18 1000000
R_L1_p_43_18 pixel_43 l1_psum_18 1000000
R_L1_p_44_18 pixel_44 l1_psum_18 388888.88888888888
R_L1_p_45_18 pixel_45 l1_psum_18 388888.88888888888
R_L1_p_46_18 pixel_46 l1_psum_18 1000000
R_L1_p_47_18 pixel_47 l1_psum_18 1000000
R_L1_p_48_18 pixel_48 l1_psum_18 1000000
R_L1_p_49_18 pixel_49 l1_psum_18 1000000
R_L1_p_50_18 pixel_50 l1_psum_18 1000000
R_L1_p_51_18 pixel_51 l1_psum_18 241379.31034482759
R_L1_p_52_18 pixel_52 l1_psum_18 241379.31034482759
R_L1_p_53_18 pixel_53 l1_psum_18 175000.00000000003
R_L1_p_54_18 pixel_54 l1_psum_18 137254.90196078431
R_L1_p_55_18 pixel_55 l1_psum_18 1000000
R_L1_p_56_18 pixel_56 l1_psum_18 50359.712230215831
R_L1_p_57_18 pixel_57 l1_psum_18 137254.90196078431
R_L1_p_58_18 pixel_58 l1_psum_18 38251.366120218576
R_L1_p_59_18 pixel_59 l1_psum_18 43478.260869565216
R_L1_p_60_18 pixel_60 l1_psum_18 22222.222222222223
R_L1_p_61_18 pixel_61 l1_psum_18 83333.333333333328
R_L1_p_62_18 pixel_62 l1_psum_18 1000000
R_L1_p_63_18 pixel_63 l1_psum_18 388888.88888888888
E_TIA_L1_p_18 l1_pout_18 0 0 l1_psum_18 100000000
R_FB_L1_p_18 l1_pout_18 l1_psum_18 1000
R_L1_m_0_18 pixel_0 l1_msum_18 46666.666666666664
R_L1_m_1_18 pixel_1 l1_msum_18 1000000
R_L1_m_2_18 pixel_2 l1_msum_18 38251.366120218576
R_L1_m_3_18 pixel_3 l1_msum_18 20771.51335311573
R_L1_m_4_18 pixel_4 l1_msum_18 24822.695035460994
R_L1_m_5_18 pixel_5 l1_msum_18 1000000
R_L1_m_6_18 pixel_6 l1_msum_18 1000000
R_L1_m_7_18 pixel_7 l1_msum_18 43478.260869565216
R_L1_m_8_18 pixel_8 l1_msum_18 1000000
R_L1_m_9_18 pixel_9 l1_msum_18 112903.22580645159
R_L1_m_10_18 pixel_10 l1_msum_18 1000000
R_L1_m_11_18 pixel_11 l1_msum_18 1000000
R_L1_m_12_18 pixel_12 l1_msum_18 1000000
R_L1_m_13_18 pixel_13 l1_msum_18 1000000
R_L1_m_14_18 pixel_14 l1_msum_18 1000000
R_L1_m_15_18 pixel_15 l1_msum_18 1000000
R_L1_m_16_18 pixel_16 l1_msum_18 83333.333333333328
R_L1_m_17_18 pixel_17 l1_msum_18 1000000
R_L1_m_18_18 pixel_18 l1_msum_18 1000000
R_L1_m_19_18 pixel_19 l1_msum_18 1000000
R_L1_m_20_18 pixel_20 l1_msum_18 388888.88888888888
R_L1_m_21_18 pixel_21 l1_msum_18 112903.22580645159
R_L1_m_22_18 pixel_22 l1_msum_18 95890.410958904104
R_L1_m_23_18 pixel_23 l1_msum_18 1000000
R_L1_m_24_18 pixel_24 l1_msum_18 1000000
R_L1_m_25_18 pixel_25 l1_msum_18 1000000
R_L1_m_26_18 pixel_26 l1_msum_18 1000000
R_L1_m_27_18 pixel_27 l1_msum_18 1000000
R_L1_m_28_18 pixel_28 l1_msum_18 1000000
R_L1_m_29_18 pixel_29 l1_msum_18 1000000
R_L1_m_30_18 pixel_30 l1_msum_18 137254.90196078431
R_L1_m_31_18 pixel_31 l1_msum_18 59829.059829059821
R_L1_m_32_18 pixel_32 l1_msum_18 137254.90196078431
R_L1_m_33_18 pixel_33 l1_msum_18 95890.410958904104
R_L1_m_34_18 pixel_34 l1_msum_18 1000000
R_L1_m_35_18 pixel_35 l1_msum_18 1000000
R_L1_m_36_18 pixel_36 l1_msum_18 1000000
R_L1_m_37_18 pixel_37 l1_msum_18 1000000
R_L1_m_38_18 pixel_38 l1_msum_18 241379.31034482759
R_L1_m_39_18 pixel_39 l1_msum_18 30837.004405286345
R_L1_m_40_18 pixel_40 l1_msum_18 32407.407407407409
R_L1_m_41_18 pixel_41 l1_msum_18 112903.22580645159
R_L1_m_42_18 pixel_42 l1_msum_18 137254.90196078431
R_L1_m_43_18 pixel_43 l1_msum_18 175000.00000000003
R_L1_m_44_18 pixel_44 l1_msum_18 1000000
R_L1_m_45_18 pixel_45 l1_msum_18 1000000
R_L1_m_46_18 pixel_46 l1_msum_18 175000.00000000003
R_L1_m_47_18 pixel_47 l1_msum_18 29411.764705882353
R_L1_m_48_18 pixel_48 l1_msum_18 23890.784982935158
R_L1_m_49_18 pixel_49 l1_msum_18 66037.735849056597
R_L1_m_50_18 pixel_50 l1_msum_18 137254.90196078431
R_L1_m_51_18 pixel_51 l1_msum_18 1000000
R_L1_m_52_18 pixel_52 l1_msum_18 1000000
R_L1_m_53_18 pixel_53 l1_msum_18 1000000
R_L1_m_54_18 pixel_54 l1_msum_18 1000000
R_L1_m_55_18 pixel_55 l1_msum_18 28112.449799196787
R_L1_m_56_18 pixel_56 l1_msum_18 1000000
R_L1_m_57_18 pixel_57 l1_msum_18 1000000
R_L1_m_58_18 pixel_58 l1_msum_18 1000000
R_L1_m_59_18 pixel_59 l1_msum_18 1000000
R_L1_m_60_18 pixel_60 l1_msum_18 1000000
R_L1_m_61_18 pixel_61 l1_msum_18 1000000
R_L1_m_62_18 pixel_62 l1_msum_18 1000000
R_L1_m_63_18 pixel_63 l1_msum_18 1000000
E_TIA_L1_m_18 l1_mout_18 0 0 l1_msum_18 100000000
R_FB_L1_m_18 l1_mout_18 l1_msum_18 1000
B_NEURON_L1_18 hidden_18 0 V={0.01*max(((V(l1_mout_18)-V(l1_pout_18))/0.0030903275574088963+(0.23433826863765717)),0)}
R_L1_p_0_19 pixel_0 l1_psum_19 112903.22580645159
R_L1_p_1_19 pixel_1 l1_psum_19 1000000
R_L1_p_2_19 pixel_2 l1_psum_19 28112.449799196787
R_L1_p_3_19 pixel_3 l1_psum_19 66037.735849056597
R_L1_p_4_19 pixel_4 l1_psum_19 1000000
R_L1_p_5_19 pixel_5 l1_psum_19 1000000
R_L1_p_6_19 pixel_6 l1_psum_19 1000000
R_L1_p_7_19 pixel_7 l1_psum_19 30837.004405286345
R_L1_p_8_19 pixel_8 l1_psum_19 73684.210526315786
R_L1_p_9_19 pixel_9 l1_psum_19 54687.499999999993
R_L1_p_10_19 pixel_10 l1_psum_19 36082.474226804123
R_L1_p_11_19 pixel_11 l1_psum_19 54687.499999999993
R_L1_p_12_19 pixel_12 l1_psum_19 40697.674418604649
R_L1_p_13_19 pixel_13 l1_psum_19 241379.31034482759
R_L1_p_14_19 pixel_14 l1_psum_19 1000000
R_L1_p_15_19 pixel_15 l1_psum_19 36082.474226804123
R_L1_p_16_19 pixel_16 l1_psum_19 83333.333333333328
R_L1_p_17_19 pixel_17 l1_psum_19 1000000
R_L1_p_18_19 pixel_18 l1_psum_19 50359.712230215831
R_L1_p_19_19 pixel_19 l1_psum_19 40697.674418604649
R_L1_p_20_19 pixel_20 l1_psum_19 43478.260869565216
R_L1_p_21_19 pixel_21 l1_psum_19 66037.735849056597
R_L1_p_22_19 pixel_22 l1_psum_19 1000000
R_L1_p_23_19 pixel_23 l1_psum_19 1000000
R_L1_p_24_19 pixel_24 l1_psum_19 1000000
R_L1_p_25_19 pixel_25 l1_psum_19 1000000
R_L1_p_26_19 pixel_26 l1_psum_19 1000000
R_L1_p_27_19 pixel_27 l1_psum_19 1000000
R_L1_p_28_19 pixel_28 l1_psum_19 1000000
R_L1_p_29_19 pixel_29 l1_psum_19 1000000
R_L1_p_30_19 pixel_30 l1_psum_19 1000000
R_L1_p_31_19 pixel_31 l1_psum_19 1000000
R_L1_p_32_19 pixel_32 l1_psum_19 1000000
R_L1_p_33_19 pixel_33 l1_psum_19 1000000
R_L1_p_34_19 pixel_34 l1_psum_19 175000.00000000003
R_L1_p_35_19 pixel_35 l1_psum_19 241379.31034482759
R_L1_p_36_19 pixel_36 l1_psum_19 1000000
R_L1_p_37_19 pixel_37 l1_psum_19 1000000
R_L1_p_38_19 pixel_38 l1_psum_19 1000000
R_L1_p_39_19 pixel_39 l1_psum_19 54687.499999999993
R_L1_p_40_19 pixel_40 l1_psum_19 59829.059829059821
R_L1_p_41_19 pixel_41 l1_psum_19 1000000
R_L1_p_42_19 pixel_42 l1_psum_19 1000000
R_L1_p_43_19 pixel_43 l1_psum_19 1000000
R_L1_p_44_19 pixel_44 l1_psum_19 1000000
R_L1_p_45_19 pixel_45 l1_psum_19 1000000
R_L1_p_46_19 pixel_46 l1_psum_19 40697.674418604649
R_L1_p_47_19 pixel_47 l1_psum_19 175000.00000000003
R_L1_p_48_19 pixel_48 l1_psum_19 24822.695035460994
R_L1_p_49_19 pixel_49 l1_psum_19 59829.059829059821
R_L1_p_50_19 pixel_50 l1_psum_19 54687.499999999993
R_L1_p_51_19 pixel_51 l1_psum_19 32407.407407407409
R_L1_p_52_19 pixel_52 l1_psum_19 32407.407407407409
R_L1_p_53_19 pixel_53 l1_psum_19 50359.712230215831
R_L1_p_54_19 pixel_54 l1_psum_19 30837.004405286345
R_L1_p_55_19 pixel_55 l1_psum_19 95890.410958904104
R_L1_p_56_19 pixel_56 l1_psum_19 73684.210526315786
R_L1_p_57_19 pixel_57 l1_psum_19 83333.333333333328
R_L1_p_58_19 pixel_58 l1_psum_19 32407.407407407409
R_L1_p_59_19 pixel_59 l1_psum_19 40697.674418604649
R_L1_p_60_19 pixel_60 l1_psum_19 34146.341463414632
R_L1_p_61_19 pixel_61 l1_psum_19 59829.059829059821
R_L1_p_62_19 pixel_62 l1_psum_19 54687.499999999993
R_L1_p_63_19 pixel_63 l1_psum_19 112903.22580645159
E_TIA_L1_p_19 l1_pout_19 0 0 l1_psum_19 100000000
R_FB_L1_p_19 l1_pout_19 l1_psum_19 1000
R_L1_m_0_19 pixel_0 l1_msum_19 1000000
R_L1_m_1_19 pixel_1 l1_msum_19 83333.333333333328
R_L1_m_2_19 pixel_2 l1_msum_19 1000000
R_L1_m_3_19 pixel_3 l1_msum_19 1000000
R_L1_m_4_19 pixel_4 l1_msum_19 112903.22580645159
R_L1_m_5_19 pixel_5 l1_msum_19 241379.31034482759
R_L1_m_6_19 pixel_6 l1_msum_19 83333.333333333328
R_L1_m_7_19 pixel_7 l1_msum_19 1000000
R_L1_m_8_19 pixel_8 l1_msum_19 1000000
R_L1_m_9_19 pixel_9 l1_msum_19 1000000
R_L1_m_10_19 pixel_10 l1_msum_19 1000000
R_L1_m_11_19 pixel_11 l1_msum_19 1000000
R_L1_m_12_19 pixel_12 l1_msum_19 1000000
R_L1_m_13_19 pixel_13 l1_msum_19 1000000
R_L1_m_14_19 pixel_14 l1_msum_19 241379.31034482759
R_L1_m_15_19 pixel_15 l1_msum_19 1000000
R_L1_m_16_19 pixel_16 l1_msum_19 1000000
R_L1_m_17_19 pixel_17 l1_msum_19 1000000
R_L1_m_18_19 pixel_18 l1_msum_19 1000000
R_L1_m_19_19 pixel_19 l1_msum_19 1000000
R_L1_m_20_19 pixel_20 l1_msum_19 1000000
R_L1_m_21_19 pixel_21 l1_msum_19 1000000
R_L1_m_22_19 pixel_22 l1_msum_19 388888.88888888888
R_L1_m_23_19 pixel_23 l1_msum_19 175000.00000000003
R_L1_m_24_19 pixel_24 l1_msum_19 112903.22580645159
R_L1_m_25_19 pixel_25 l1_msum_19 38251.366120218576
R_L1_m_26_19 pixel_26 l1_msum_19 46666.666666666664
R_L1_m_27_19 pixel_27 l1_msum_19 36082.474226804123
R_L1_m_28_19 pixel_28 l1_msum_19 29411.764705882353
R_L1_m_29_19 pixel_29 l1_msum_19 83333.333333333328
R_L1_m_30_19 pixel_30 l1_msum_19 34146.341463414632
R_L1_m_31_19 pixel_31 l1_msum_19 388888.88888888888
R_L1_m_32_19 pixel_32 l1_msum_19 23890.784982935158
R_L1_m_33_19 pixel_33 l1_msum_19 83333.333333333328
R_L1_m_34_19 pixel_34 l1_msum_19 1000000
R_L1_m_35_19 pixel_35 l1_msum_19 1000000
R_L1_m_36_19 pixel_36 l1_msum_19 66037.735849056597
R_L1_m_37_19 pixel_37 l1_msum_19 66037.735849056597
R_L1_m_38_19 pixel_38 l1_msum_19 43478.260869565216
R_L1_m_39_19 pixel_39 l1_msum_19 1000000
R_L1_m_40_19 pixel_40 l1_msum_19 1000000
R_L1_m_41_19 pixel_41 l1_msum_19 95890.410958904104
R_L1_m_42_19 pixel_42 l1_msum_19 241379.31034482759
R_L1_m_43_19 pixel_43 l1_msum_19 95890.410958904104
R_L1_m_44_19 pixel_44 l1_msum_19 388888.88888888888
R_L1_m_45_19 pixel_45 l1_msum_19 388888.88888888888
R_L1_m_46_19 pixel_46 l1_msum_19 1000000
R_L1_m_47_19 pixel_47 l1_msum_19 1000000
R_L1_m_48_19 pixel_48 l1_msum_19 1000000
R_L1_m_49_19 pixel_49 l1_msum_19 1000000
R_L1_m_50_19 pixel_50 l1_msum_19 1000000
R_L1_m_51_19 pixel_51 l1_msum_19 1000000
R_L1_m_52_19 pixel_52 l1_msum_19 1000000
R_L1_m_53_19 pixel_53 l1_msum_19 1000000
R_L1_m_54_19 pixel_54 l1_msum_19 1000000
R_L1_m_55_19 pixel_55 l1_msum_19 1000000
R_L1_m_56_19 pixel_56 l1_msum_19 1000000
R_L1_m_57_19 pixel_57 l1_msum_19 1000000
R_L1_m_58_19 pixel_58 l1_msum_19 1000000
R_L1_m_59_19 pixel_59 l1_msum_19 1000000
R_L1_m_60_19 pixel_60 l1_msum_19 1000000
R_L1_m_61_19 pixel_61 l1_msum_19 1000000
R_L1_m_62_19 pixel_62 l1_msum_19 1000000
R_L1_m_63_19 pixel_63 l1_msum_19 1000000
E_TIA_L1_m_19 l1_mout_19 0 0 l1_msum_19 100000000
R_FB_L1_m_19 l1_mout_19 l1_msum_19 1000
B_NEURON_L1_19 hidden_19 0 V={0.01*max(((V(l1_mout_19)-V(l1_pout_19))/0.0030903275574088963+(0.027620457112789154)),0)}
R_L1_p_0_20 pixel_0 l1_psum_20 83333.333333333328
R_L1_p_1_20 pixel_1 l1_psum_20 30837.004405286345
R_L1_p_2_20 pixel_2 l1_psum_20 23890.784982935158
R_L1_p_3_20 pixel_3 l1_psum_20 32407.407407407409
R_L1_p_4_20 pixel_4 l1_psum_20 36082.474226804123
R_L1_p_5_20 pixel_5 l1_psum_20 30837.004405286345
R_L1_p_6_20 pixel_6 l1_psum_20 50359.712230215831
R_L1_p_7_20 pixel_7 l1_psum_20 50359.712230215831
R_L1_p_8_20 pixel_8 l1_psum_20 50359.712230215831
R_L1_p_9_20 pixel_9 l1_psum_20 50359.712230215831
R_L1_p_10_20 pixel_10 l1_psum_20 46666.666666666664
R_L1_p_11_20 pixel_11 l1_psum_20 40697.674418604649
R_L1_p_12_20 pixel_12 l1_psum_20 46666.666666666664
R_L1_p_13_20 pixel_13 l1_psum_20 241379.31034482759
R_L1_p_14_20 pixel_14 l1_psum_20 1000000
R_L1_p_15_20 pixel_15 l1_psum_20 1000000
R_L1_p_16_20 pixel_16 l1_psum_20 32407.407407407409
R_L1_p_17_20 pixel_17 l1_psum_20 1000000
R_L1_p_18_20 pixel_18 l1_psum_20 388888.88888888888
R_L1_p_19_20 pixel_19 l1_psum_20 1000000
R_L1_p_20_20 pixel_20 l1_psum_20 1000000
R_L1_p_21_20 pixel_21 l1_psum_20 1000000
R_L1_p_22_20 pixel_22 l1_psum_20 1000000
R_L1_p_23_20 pixel_23 l1_psum_20 1000000
R_L1_p_24_20 pixel_24 l1_psum_20 1000000
R_L1_p_25_20 pixel_25 l1_psum_20 1000000
R_L1_p_26_20 pixel_26 l1_psum_20 1000000
R_L1_p_27_20 pixel_27 l1_psum_20 1000000
R_L1_p_28_20 pixel_28 l1_psum_20 137254.90196078431
R_L1_p_29_20 pixel_29 l1_psum_20 1000000
R_L1_p_30_20 pixel_30 l1_psum_20 1000000
R_L1_p_31_20 pixel_31 l1_psum_20 175000.00000000003
R_L1_p_32_20 pixel_32 l1_psum_20 43478.260869565216
R_L1_p_33_20 pixel_33 l1_psum_20 40697.674418604649
R_L1_p_34_20 pixel_34 l1_psum_20 1000000
R_L1_p_35_20 pixel_35 l1_psum_20 66037.735849056597
R_L1_p_36_20 pixel_36 l1_psum_20 36082.474226804123
R_L1_p_37_20 pixel_37 l1_psum_20 175000.00000000003
R_L1_p_38_20 pixel_38 l1_psum_20 1000000
R_L1_p_39_20 pixel_39 l1_psum_20 38251.366120218576
R_L1_p_40_20 pixel_40 l1_psum_20 46666.666666666664
R_L1_p_41_20 pixel_41 l1_psum_20 59829.059829059821
R_L1_p_42_20 pixel_42 l1_psum_20 54687.499999999993
R_L1_p_43_20 pixel_43 l1_psum_20 59829.059829059821
R_L1_p_44_20 pixel_44 l1_psum_20 50359.712230215831
R_L1_p_45_20 pixel_45 l1_psum_20 1000000
R_L1_p_46_20 pixel_46 l1_psum_20 1000000
R_L1_p_47_20 pixel_47 l1_psum_20 23026.315789473687
R_L1_p_48_20 pixel_48 l1_psum_20 137254.90196078431
R_L1_p_49_20 pixel_49 l1_psum_20 175000.00000000003
R_L1_p_50_20 pixel_50 l1_psum_20 73684.210526315786
R_L1_p_51_20 pixel_51 l1_psum_20 175000.00000000003
R_L1_p_52_20 pixel_52 l1_psum_20 1000000
R_L1_p_53_20 pixel_53 l1_psum_20 1000000
R_L1_p_54_20 pixel_54 l1_psum_20 1000000
R_L1_p_55_20 pixel_55 l1_psum_20 137254.90196078431
R_L1_p_56_20 pixel_56 l1_psum_20 54687.499999999993
R_L1_p_57_20 pixel_57 l1_psum_20 43478.260869565216
R_L1_p_58_20 pixel_58 l1_psum_20 73684.210526315786
R_L1_p_59_20 pixel_59 l1_psum_20 38251.366120218576
R_L1_p_60_20 pixel_60 l1_psum_20 34146.341463414632
R_L1_p_61_20 pixel_61 l1_psum_20 1000000
R_L1_p_62_20 pixel_62 l1_psum_20 388888.88888888888
R_L1_p_63_20 pixel_63 l1_psum_20 1000000
E_TIA_L1_p_20 l1_pout_20 0 0 l1_psum_20 100000000
R_FB_L1_p_20 l1_pout_20 l1_psum_20 1000
R_L1_m_0_20 pixel_0 l1_msum_20 1000000
R_L1_m_1_20 pixel_1 l1_msum_20 1000000
R_L1_m_2_20 pixel_2 l1_msum_20 1000000
R_L1_m_3_20 pixel_3 l1_msum_20 1000000
R_L1_m_4_20 pixel_4 l1_msum_20 1000000
R_L1_m_5_20 pixel_5 l1_msum_20 1000000
R_L1_m_6_20 pixel_6 l1_msum_20 1000000
R_L1_m_7_20 pixel_7 l1_msum_20 1000000
R_L1_m_8_20 pixel_8 l1_msum_20 1000000
R_L1_m_9_20 pixel_9 l1_msum_20 1000000
R_L1_m_10_20 pixel_10 l1_msum_20 1000000
R_L1_m_11_20 pixel_11 l1_msum_20 1000000
R_L1_m_12_20 pixel_12 l1_msum_20 1000000
R_L1_m_13_20 pixel_13 l1_msum_20 1000000
R_L1_m_14_20 pixel_14 l1_msum_20 241379.31034482759
R_L1_m_15_20 pixel_15 l1_msum_20 241379.31034482759
R_L1_m_16_20 pixel_16 l1_msum_20 1000000
R_L1_m_17_20 pixel_17 l1_msum_20 388888.88888888888
R_L1_m_18_20 pixel_18 l1_msum_20 1000000
R_L1_m_19_20 pixel_19 l1_msum_20 46666.666666666664
R_L1_m_20_20 pixel_20 l1_msum_20 83333.333333333328
R_L1_m_21_20 pixel_21 l1_msum_20 137254.90196078431
R_L1_m_22_20 pixel_22 l1_msum_20 137254.90196078431
R_L1_m_23_20 pixel_23 l1_msum_20 19498.607242339833
R_L1_m_24_20 pixel_24 l1_msum_20 112903.22580645159
R_L1_m_25_20 pixel_25 l1_msum_20 32407.407407407409
R_L1_m_26_20 pixel_26 l1_msum_20 23890.784982935158
R_L1_m_27_20 pixel_27 l1_msum_20 25830.258302583028
R_L1_m_28_20 pixel_28 l1_msum_20 1000000
R_L1_m_29_20 pixel_29 l1_msum_20 241379.31034482759
R_L1_m_30_20 pixel_30 l1_msum_20 1000000
R_L1_m_31_20 pixel_31 l1_msum_20 1000000
R_L1_m_32_20 pixel_32 l1_msum_20 1000000
R_L1_m_33_20 pixel_33 l1_msum_20 1000000
R_L1_m_34_20 pixel_34 l1_msum_20 83333.333333333328
R_L1_m_35_20 pixel_35 l1_msum_20 1000000
R_L1_m_36_20 pixel_36 l1_msum_20 1000000
R_L1_m_37_20 pixel_37 l1_msum_20 1000000
R_L1_m_38_20 pixel_38 l1_msum_20 388888.88888888888
R_L1_m_39_20 pixel_39 l1_msum_20 1000000
R_L1_m_40_20 pixel_40 l1_msum_20 1000000
R_L1_m_41_20 pixel_41 l1_msum_20 1000000
R_L1_m_42_20 pixel_42 l1_msum_20 1000000
R_L1_m_43_20 pixel_43 l1_msum_20 1000000
R_L1_m_44_20 pixel_44 l1_msum_20 1000000
R_L1_m_45_20 pixel_45 l1_msum_20 241379.31034482759
R_L1_m_46_20 pixel_46 l1_msum_20 241379.31034482759
R_L1_m_47_20 pixel_47 l1_msum_20 1000000
R_L1_m_48_20 pixel_48 l1_msum_20 1000000
R_L1_m_49_20 pixel_49 l1_msum_20 1000000
R_L1_m_50_20 pixel_50 l1_msum_20 1000000
R_L1_m_51_20 pixel_51 l1_msum_20 1000000
R_L1_m_52_20 pixel_52 l1_msum_20 241379.31034482759
R_L1_m_53_20 pixel_53 l1_msum_20 241379.31034482759
R_L1_m_54_20 pixel_54 l1_msum_20 175000.00000000003
R_L1_m_55_20 pixel_55 l1_msum_20 1000000
R_L1_m_56_20 pixel_56 l1_msum_20 1000000
R_L1_m_57_20 pixel_57 l1_msum_20 1000000
R_L1_m_58_20 pixel_58 l1_msum_20 1000000
R_L1_m_59_20 pixel_59 l1_msum_20 1000000
R_L1_m_60_20 pixel_60 l1_msum_20 1000000
R_L1_m_61_20 pixel_61 l1_msum_20 40697.674418604649
R_L1_m_62_20 pixel_62 l1_msum_20 1000000
R_L1_m_63_20 pixel_63 l1_msum_20 1000000
E_TIA_L1_m_20 l1_mout_20 0 0 l1_msum_20 100000000
R_FB_L1_m_20 l1_mout_20 l1_msum_20 1000
B_NEURON_L1_20 hidden_20 0 V={0.01*max(((V(l1_mout_20)-V(l1_pout_20))/0.0030903275574088963+(-0.12758097052574158)),0)}
R_L1_p_0_21 pixel_0 l1_psum_21 1000000
R_L1_p_1_21 pixel_1 l1_psum_21 1000000
R_L1_p_2_21 pixel_2 l1_psum_21 1000000
R_L1_p_3_21 pixel_3 l1_psum_21 1000000
R_L1_p_4_21 pixel_4 l1_psum_21 1000000
R_L1_p_5_21 pixel_5 l1_psum_21 50359.712230215831
R_L1_p_6_21 pixel_6 l1_psum_21 1000000
R_L1_p_7_21 pixel_7 l1_psum_21 1000000
R_L1_p_8_21 pixel_8 l1_psum_21 28112.449799196787
R_L1_p_9_21 pixel_9 l1_psum_21 175000.00000000003
R_L1_p_10_21 pixel_10 l1_psum_21 73684.210526315786
R_L1_p_11_21 pixel_11 l1_psum_21 137254.90196078431
R_L1_p_12_21 pixel_12 l1_psum_21 1000000
R_L1_p_13_21 pixel_13 l1_psum_21 40697.674418604649
R_L1_p_14_21 pixel_14 l1_psum_21 95890.410958904104
R_L1_p_15_21 pixel_15 l1_psum_21 1000000
R_L1_p_16_21 pixel_16 l1_psum_21 38251.366120218576
R_L1_p_17_21 pixel_17 l1_psum_21 137254.90196078431
R_L1_p_18_21 pixel_18 l1_psum_21 1000000
R_L1_p_19_21 pixel_19 l1_psum_21 175000.00000000003
R_L1_p_20_21 pixel_20 l1_psum_21 1000000
R_L1_p_21_21 pixel_21 l1_psum_21 34146.341463414632
R_L1_p_22_21 pixel_22 l1_psum_21 1000000
R_L1_p_23_21 pixel_23 l1_psum_21 83333.333333333328
R_L1_p_24_21 pixel_24 l1_psum_21 388888.88888888888
R_L1_p_25_21 pixel_25 l1_psum_21 1000000
R_L1_p_26_21 pixel_26 l1_psum_21 1000000
R_L1_p_27_21 pixel_27 l1_psum_21 95890.410958904104
R_L1_p_28_21 pixel_28 l1_psum_21 1000000
R_L1_p_29_21 pixel_29 l1_psum_21 1000000
R_L1_p_30_21 pixel_30 l1_psum_21 1000000
R_L1_p_31_21 pixel_31 l1_psum_21 1000000
R_L1_p_32_21 pixel_32 l1_psum_21 54687.499999999993
R_L1_p_33_21 pixel_33 l1_psum_21 59829.059829059821
R_L1_p_34_21 pixel_34 l1_psum_21 388888.88888888888
R_L1_p_35_21 pixel_35 l1_psum_21 1000000
R_L1_p_36_21 pixel_36 l1_psum_21 59829.059829059821
R_L1_p_37_21 pixel_37 l1_psum_21 1000000
R_L1_p_38_21 pixel_38 l1_psum_21 66037.735849056597
R_L1_p_39_21 pixel_39 l1_psum_21 1000000
R_L1_p_40_21 pixel_40 l1_psum_21 38251.366120218576
R_L1_p_41_21 pixel_41 l1_psum_21 241379.31034482759
R_L1_p_42_21 pixel_42 l1_psum_21 1000000
R_L1_p_43_21 pixel_43 l1_psum_21 1000000
R_L1_p_44_21 pixel_44 l1_psum_21 1000000
R_L1_p_45_21 pixel_45 l1_psum_21 241379.31034482759
R_L1_p_46_21 pixel_46 l1_psum_21 241379.31034482759
R_L1_p_47_21 pixel_47 l1_psum_21 1000000
R_L1_p_48_21 pixel_48 l1_psum_21 29411.764705882353
R_L1_p_49_21 pixel_49 l1_psum_21 83333.333333333328
R_L1_p_50_21 pixel_50 l1_psum_21 112903.22580645159
R_L1_p_51_21 pixel_51 l1_psum_21 1000000
R_L1_p_52_21 pixel_52 l1_psum_21 59829.059829059821
R_L1_p_53_21 pixel_53 l1_psum_21 40697.674418604649
R_L1_p_54_21 pixel_54 l1_psum_21 1000000
R_L1_p_55_21 pixel_55 l1_psum_21 1000000
R_L1_p_56_21 pixel_56 l1_psum_21 388888.88888888888
R_L1_p_57_21 pixel_57 l1_psum_21 1000000
R_L1_p_58_21 pixel_58 l1_psum_21 1000000
R_L1_p_59_21 pixel_59 l1_psum_21 388888.88888888888
R_L1_p_60_21 pixel_60 l1_psum_21 1000000
R_L1_p_61_21 pixel_61 l1_psum_21 1000000
R_L1_p_62_21 pixel_62 l1_psum_21 1000000
R_L1_p_63_21 pixel_63 l1_psum_21 1000000
E_TIA_L1_p_21 l1_pout_21 0 0 l1_psum_21 100000000
R_FB_L1_p_21 l1_pout_21 l1_psum_21 1000
R_L1_m_0_21 pixel_0 l1_msum_21 388888.88888888888
R_L1_m_1_21 pixel_1 l1_msum_21 26923.076923076922
R_L1_m_2_21 pixel_2 l1_msum_21 14583.333333333334
R_L1_m_3_21 pixel_3 l1_msum_21 21472.39263803681
R_L1_m_4_21 pixel_4 l1_msum_21 83333.333333333328
R_L1_m_5_21 pixel_5 l1_msum_21 1000000
R_L1_m_6_21 pixel_6 l1_msum_21 66037.735849056597
R_L1_m_7_21 pixel_7 l1_msum_21 30837.004405286345
R_L1_m_8_21 pixel_8 l1_msum_21 1000000
R_L1_m_9_21 pixel_9 l1_msum_21 1000000
R_L1_m_10_21 pixel_10 l1_msum_21 1000000
R_L1_m_11_21 pixel_11 l1_msum_21 1000000
R_L1_m_12_21 pixel_12 l1_msum_21 21472.39263803681
R_L1_m_13_21 pixel_13 l1_msum_21 1000000
R_L1_m_14_21 pixel_14 l1_msum_21 1000000
R_L1_m_15_21 pixel_15 l1_msum_21 175000.00000000003
R_L1_m_16_21 pixel_16 l1_msum_21 1000000
R_L1_m_17_21 pixel_17 l1_msum_21 1000000
R_L1_m_18_21 pixel_18 l1_msum_21 83333.333333333328
R_L1_m_19_21 pixel_19 l1_msum_21 1000000
R_L1_m_20_21 pixel_20 l1_msum_21 24822.695035460994
R_L1_m_21_21 pixel_21 l1_msum_21 1000000
R_L1_m_22_21 pixel_22 l1_msum_21 175000.00000000003
R_L1_m_23_21 pixel_23 l1_msum_21 1000000
R_L1_m_24_21 pixel_24 l1_msum_21 1000000
R_L1_m_25_21 pixel_25 l1_msum_21 112903.22580645159
R_L1_m_26_21 pixel_26 l1_msum_21 241379.31034482759
R_L1_m_27_21 pixel_27 l1_msum_21 1000000
R_L1_m_28_21 pixel_28 l1_msum_21 1000000
R_L1_m_29_21 pixel_29 l1_msum_21 1000000
R_L1_m_30_21 pixel_30 l1_msum_21 36082.474226804123
R_L1_m_31_21 pixel_31 l1_msum_21 36082.474226804123
R_L1_m_32_21 pixel_32 l1_msum_21 1000000
R_L1_m_33_21 pixel_33 l1_msum_21 1000000
R_L1_m_34_21 pixel_34 l1_msum_21 1000000
R_L1_m_35_21 pixel_35 l1_msum_21 137254.90196078431
R_L1_m_36_21 pixel_36 l1_msum_21 1000000
R_L1_m_37_21 pixel_37 l1_msum_21 388888.88888888888
R_L1_m_38_21 pixel_38 l1_msum_21 1000000
R_L1_m_39_21 pixel_39 l1_msum_21 40697.674418604649
R_L1_m_40_21 pixel_40 l1_msum_21 1000000
R_L1_m_41_21 pixel_41 l1_msum_21 1000000
R_L1_m_42_21 pixel_42 l1_msum_21 66037.735849056597
R_L1_m_43_21 pixel_43 l1_msum_21 50359.712230215831
R_L1_m_44_21 pixel_44 l1_msum_21 1000000
R_L1_m_45_21 pixel_45 l1_msum_21 1000000
R_L1_m_46_21 pixel_46 l1_msum_21 1000000
R_L1_m_47_21 pixel_47 l1_msum_21 40697.674418604649
R_L1_m_48_21 pixel_48 l1_msum_21 1000000
R_L1_m_49_21 pixel_49 l1_msum_21 1000000
R_L1_m_50_21 pixel_50 l1_msum_21 1000000
R_L1_m_51_21 pixel_51 l1_msum_21 388888.88888888888
R_L1_m_52_21 pixel_52 l1_msum_21 1000000
R_L1_m_53_21 pixel_53 l1_msum_21 1000000
R_L1_m_54_21 pixel_54 l1_msum_21 241379.31034482759
R_L1_m_55_21 pixel_55 l1_msum_21 73684.210526315786
R_L1_m_56_21 pixel_56 l1_msum_21 1000000
R_L1_m_57_21 pixel_57 l1_msum_21 38251.366120218576
R_L1_m_58_21 pixel_58 l1_msum_21 59829.059829059821
R_L1_m_59_21 pixel_59 l1_msum_21 1000000
R_L1_m_60_21 pixel_60 l1_msum_21 112903.22580645159
R_L1_m_61_21 pixel_61 l1_msum_21 73684.210526315786
R_L1_m_62_21 pixel_62 l1_msum_21 175000.00000000003
R_L1_m_63_21 pixel_63 l1_msum_21 137254.90196078431
E_TIA_L1_m_21 l1_mout_21 0 0 l1_msum_21 100000000
R_FB_L1_m_21 l1_mout_21 l1_msum_21 1000
B_NEURON_L1_21 hidden_21 0 V={0.01*max(((V(l1_mout_21)-V(l1_pout_21))/0.0030903275574088963+(0.23996445536613464)),0)}
R_L1_p_0_22 pixel_0 l1_psum_22 1000000
R_L1_p_1_22 pixel_1 l1_psum_22 1000000
R_L1_p_2_22 pixel_2 l1_psum_22 1000000
R_L1_p_3_22 pixel_3 l1_psum_22 1000000
R_L1_p_4_22 pixel_4 l1_psum_22 1000000
R_L1_p_5_22 pixel_5 l1_psum_22 137254.90196078431
R_L1_p_6_22 pixel_6 l1_psum_22 23026.315789473687
R_L1_p_7_22 pixel_7 l1_psum_22 1000000
R_L1_p_8_22 pixel_8 l1_psum_22 1000000
R_L1_p_9_22 pixel_9 l1_psum_22 1000000
R_L1_p_10_22 pixel_10 l1_psum_22 1000000
R_L1_p_11_22 pixel_11 l1_psum_22 1000000
R_L1_p_12_22 pixel_12 l1_psum_22 1000000
R_L1_p_13_22 pixel_13 l1_psum_22 241379.31034482759
R_L1_p_14_22 pixel_14 l1_psum_22 40697.674418604649
R_L1_p_15_22 pixel_15 l1_psum_22 18372.70341207349
R_L1_p_16_22 pixel_16 l1_psum_22 1000000
R_L1_p_17_22 pixel_17 l1_psum_22 1000000
R_L1_p_18_22 pixel_18 l1_psum_22 112903.22580645159
R_L1_p_19_22 pixel_19 l1_psum_22 73684.210526315786
R_L1_p_20_22 pixel_20 l1_psum_22 1000000
R_L1_p_21_22 pixel_21 l1_psum_22 1000000
R_L1_p_22_22 pixel_22 l1_psum_22 95890.410958904104
R_L1_p_23_22 pixel_23 l1_psum_22 19498.607242339833
R_L1_p_24_22 pixel_24 l1_psum_22 1000000
R_L1_p_25_22 pixel_25 l1_psum_22 95890.410958904104
R_L1_p_26_22 pixel_26 l1_psum_22 46666.666666666664
R_L1_p_27_22 pixel_27 l1_psum_22 241379.31034482759
R_L1_p_28_22 pixel_28 l1_psum_22 73684.210526315786
R_L1_p_29_22 pixel_29 l1_psum_22 1000000
R_L1_p_30_22 pixel_30 l1_psum_22 1000000
R_L1_p_31_22 pixel_31 l1_psum_22 1000000
R_L1_p_32_22 pixel_32 l1_psum_22 1000000
R_L1_p_33_22 pixel_33 l1_psum_22 1000000
R_L1_p_34_22 pixel_34 l1_psum_22 1000000
R_L1_p_35_22 pixel_35 l1_psum_22 73684.210526315786
R_L1_p_36_22 pixel_36 l1_psum_22 50359.712230215831
R_L1_p_37_22 pixel_37 l1_psum_22 1000000
R_L1_p_38_22 pixel_38 l1_psum_22 1000000
R_L1_p_39_22 pixel_39 l1_psum_22 1000000
R_L1_p_40_22 pixel_40 l1_psum_22 1000000
R_L1_p_41_22 pixel_41 l1_psum_22 1000000
R_L1_p_42_22 pixel_42 l1_psum_22 388888.88888888888
R_L1_p_43_22 pixel_43 l1_psum_22 54687.499999999993
R_L1_p_44_22 pixel_44 l1_psum_22 1000000
R_L1_p_45_22 pixel_45 l1_psum_22 1000000
R_L1_p_46_22 pixel_46 l1_psum_22 1000000
R_L1_p_47_22 pixel_47 l1_psum_22 1000000
R_L1_p_48_22 pixel_48 l1_psum_22 1000000
R_L1_p_49_22 pixel_49 l1_psum_22 1000000
R_L1_p_50_22 pixel_50 l1_psum_22 1000000
R_L1_p_51_22 pixel_51 l1_psum_22 1000000
R_L1_p_52_22 pixel_52 l1_psum_22 95890.410958904104
R_L1_p_53_22 pixel_53 l1_psum_22 73684.210526315786
R_L1_p_54_22 pixel_54 l1_psum_22 50359.712230215831
R_L1_p_55_22 pixel_55 l1_psum_22 1000000
R_L1_p_56_22 pixel_56 l1_psum_22 83333.333333333328
R_L1_p_57_22 pixel_57 l1_psum_22 1000000
R_L1_p_58_22 pixel_58 l1_psum_22 1000000
R_L1_p_59_22 pixel_59 l1_psum_22 1000000
R_L1_p_60_22 pixel_60 l1_psum_22 112903.22580645159
R_L1_p_61_22 pixel_61 l1_psum_22 1000000
R_L1_p_62_22 pixel_62 l1_psum_22 1000000
R_L1_p_63_22 pixel_63 l1_psum_22 137254.90196078431
E_TIA_L1_p_22 l1_pout_22 0 0 l1_psum_22 100000000
R_FB_L1_p_22 l1_pout_22 l1_psum_22 1000
R_L1_m_0_22 pixel_0 l1_msum_22 50359.712230215831
R_L1_m_1_22 pixel_1 l1_msum_22 388888.88888888888
R_L1_m_2_22 pixel_2 l1_msum_22 175000.00000000003
R_L1_m_3_22 pixel_3 l1_msum_22 73684.210526315786
R_L1_m_4_22 pixel_4 l1_msum_22 388888.88888888888
R_L1_m_5_22 pixel_5 l1_msum_22 1000000
R_L1_m_6_22 pixel_6 l1_msum_22 1000000
R_L1_m_7_22 pixel_7 l1_msum_22 95890.410958904104
R_L1_m_8_22 pixel_8 l1_msum_22 32407.407407407409
R_L1_m_9_22 pixel_9 l1_msum_22 40697.674418604649
R_L1_m_10_22 pixel_10 l1_msum_22 54687.499999999993
R_L1_m_11_22 pixel_11 l1_msum_22 112903.22580645159
R_L1_m_12_22 pixel_12 l1_msum_22 388888.88888888888
R_L1_m_13_22 pixel_13 l1_msum_22 1000000
R_L1_m_14_22 pixel_14 l1_msum_22 1000000
R_L1_m_15_22 pixel_15 l1_msum_22 1000000
R_L1_m_16_22 pixel_16 l1_msum_22 29411.764705882353
R_L1_m_17_22 pixel_17 l1_msum_22 40697.674418604649
R_L1_m_18_22 pixel_18 l1_msum_22 1000000
R_L1_m_19_22 pixel_19 l1_msum_22 1000000
R_L1_m_20_22 pixel_20 l1_msum_22 46666.666666666664
R_L1_m_21_22 pixel_21 l1_msum_22 66037.735849056597
R_L1_m_22_22 pixel_22 l1_msum_22 1000000
R_L1_m_23_22 pixel_23 l1_msum_22 1000000
R_L1_m_24_22 pixel_24 l1_msum_22 30837.004405286345
R_L1_m_25_22 pixel_25 l1_msum_22 1000000
R_L1_m_26_22 pixel_26 l1_msum_22 1000000
R_L1_m_27_22 pixel_27 l1_msum_22 1000000
R_L1_m_28_22 pixel_28 l1_msum_22 1000000
R_L1_m_29_22 pixel_29 l1_msum_22 46666.666666666664
R_L1_m_30_22 pixel_30 l1_msum_22 241379.31034482759
R_L1_m_31_22 pixel_31 l1_msum_22 388888.88888888888
R_L1_m_32_22 pixel_32 l1_msum_22 50359.712230215831
R_L1_m_33_22 pixel_33 l1_msum_22 137254.90196078431
R_L1_m_34_22 pixel_34 l1_msum_22 83333.333333333328
R_L1_m_35_22 pixel_35 l1_msum_22 1000000
R_L1_m_36_22 pixel_36 l1_msum_22 1000000
R_L1_m_37_22 pixel_37 l1_msum_22 54687.499999999993
R_L1_m_38_22 pixel_38 l1_msum_22 36082.474226804123
R_L1_m_39_22 pixel_39 l1_msum_22 46666.666666666664
R_L1_m_40_22 pixel_40 l1_msum_22 23026.315789473687
R_L1_m_41_22 pixel_41 l1_msum_22 40697.674418604649
R_L1_m_42_22 pixel_42 l1_msum_22 1000000
R_L1_m_43_22 pixel_43 l1_msum_22 1000000
R_L1_m_44_22 pixel_44 l1_msum_22 112903.22580645159
R_L1_m_45_22 pixel_45 l1_msum_22 50359.712230215831
R_L1_m_46_22 pixel_46 l1_msum_22 83333.333333333328
R_L1_m_47_22 pixel_47 l1_msum_22 50359.712230215831
R_L1_m_48_22 pixel_48 l1_msum_22 25830.258302583028
R_L1_m_49_22 pixel_49 l1_msum_22 23890.784982935158
R_L1_m_50_22 pixel_50 l1_msum_22 137254.90196078431
R_L1_m_51_22 pixel_51 l1_msum_22 175000.00000000003
R_L1_m_52_22 pixel_52 l1_msum_22 1000000
R_L1_m_53_22 pixel_53 l1_msum_22 1000000
R_L1_m_54_22 pixel_54 l1_msum_22 1000000
R_L1_m_55_22 pixel_55 l1_msum_22 83333.333333333328
R_L1_m_56_22 pixel_56 l1_msum_22 1000000
R_L1_m_57_22 pixel_57 l1_msum_22 30837.004405286345
R_L1_m_58_22 pixel_58 l1_msum_22 95890.410958904104
R_L1_m_59_22 pixel_59 l1_msum_22 83333.333333333328
R_L1_m_60_22 pixel_60 l1_msum_22 1000000
R_L1_m_61_22 pixel_61 l1_msum_22 66037.735849056597
R_L1_m_62_22 pixel_62 l1_msum_22 241379.31034482759
R_L1_m_63_22 pixel_63 l1_msum_22 1000000
E_TIA_L1_m_22 l1_mout_22 0 0 l1_msum_22 100000000
R_FB_L1_m_22 l1_mout_22 l1_msum_22 1000
B_NEURON_L1_22 hidden_22 0 V={0.01*max(((V(l1_mout_22)-V(l1_pout_22))/0.0030903275574088963+(0.35940167307853699)),0)}
R_L1_p_0_23 pixel_0 l1_psum_23 50359.712230215831
R_L1_p_1_23 pixel_1 l1_psum_23 1000000
R_L1_p_2_23 pixel_2 l1_psum_23 1000000
R_L1_p_3_23 pixel_3 l1_psum_23 1000000
R_L1_p_4_23 pixel_4 l1_psum_23 1000000
R_L1_p_5_23 pixel_5 l1_psum_23 1000000
R_L1_p_6_23 pixel_6 l1_psum_23 1000000
R_L1_p_7_23 pixel_7 l1_psum_23 1000000
R_L1_p_8_23 pixel_8 l1_psum_23 1000000
R_L1_p_9_23 pixel_9 l1_psum_23 1000000
R_L1_p_10_23 pixel_10 l1_psum_23 1000000
R_L1_p_11_23 pixel_11 l1_psum_23 388888.88888888888
R_L1_p_12_23 pixel_12 l1_psum_23 54687.499999999993
R_L1_p_13_23 pixel_13 l1_psum_23 137254.90196078431
R_L1_p_14_23 pixel_14 l1_psum_23 1000000
R_L1_p_15_23 pixel_15 l1_psum_23 1000000
R_L1_p_16_23 pixel_16 l1_psum_23 1000000
R_L1_p_17_23 pixel_17 l1_psum_23 1000000
R_L1_p_18_23 pixel_18 l1_psum_23 1000000
R_L1_p_19_23 pixel_19 l1_psum_23 83333.333333333328
R_L1_p_20_23 pixel_20 l1_psum_23 22222.222222222223
R_L1_p_21_23 pixel_21 l1_psum_23 36082.474226804123
R_L1_p_22_23 pixel_22 l1_psum_23 50359.712230215831
R_L1_p_23_23 pixel_23 l1_psum_23 1000000
R_L1_p_24_23 pixel_24 l1_psum_23 1000000
R_L1_p_25_23 pixel_25 l1_psum_23 1000000
R_L1_p_26_23 pixel_26 l1_psum_23 1000000
R_L1_p_27_23 pixel_27 l1_psum_23 1000000
R_L1_p_28_23 pixel_28 l1_psum_23 1000000
R_L1_p_29_23 pixel_29 l1_psum_23 1000000
R_L1_p_30_23 pixel_30 l1_psum_23 66037.735849056597
R_L1_p_31_23 pixel_31 l1_psum_23 1000000
R_L1_p_32_23 pixel_32 l1_psum_23 1000000
R_L1_p_33_23 pixel_33 l1_psum_23 241379.31034482759
R_L1_p_34_23 pixel_34 l1_psum_23 388888.88888888888
R_L1_p_35_23 pixel_35 l1_psum_23 1000000
R_L1_p_36_23 pixel_36 l1_psum_23 1000000
R_L1_p_37_23 pixel_37 l1_psum_23 1000000
R_L1_p_38_23 pixel_38 l1_psum_23 1000000
R_L1_p_39_23 pixel_39 l1_psum_23 95890.410958904104
R_L1_p_40_23 pixel_40 l1_psum_23 1000000
R_L1_p_41_23 pixel_41 l1_psum_23 1000000
R_L1_p_42_23 pixel_42 l1_psum_23 1000000
R_L1_p_43_23 pixel_43 l1_psum_23 1000000
R_L1_p_44_23 pixel_44 l1_psum_23 175000.00000000003
R_L1_p_45_23 pixel_45 l1_psum_23 1000000
R_L1_p_46_23 pixel_46 l1_psum_23 1000000
R_L1_p_47_23 pixel_47 l1_psum_23 17369.727047146403
R_L1_p_48_23 pixel_48 l1_psum_23 1000000
R_L1_p_49_23 pixel_49 l1_psum_23 38251.366120218576
R_L1_p_50_23 pixel_50 l1_psum_23 95890.410958904104
R_L1_p_51_23 pixel_51 l1_psum_23 241379.31034482759
R_L1_p_52_23 pixel_52 l1_psum_23 1000000
R_L1_p_53_23 pixel_53 l1_psum_23 1000000
R_L1_p_54_23 pixel_54 l1_psum_23 1000000
R_L1_p_55_23 pixel_55 l1_psum_23 32407.407407407409
R_L1_p_56_23 pixel_56 l1_psum_23 59829.059829059821
R_L1_p_57_23 pixel_57 l1_psum_23 73684.210526315786
R_L1_p_58_23 pixel_58 l1_psum_23 388888.88888888888
R_L1_p_59_23 pixel_59 l1_psum_23 175000.00000000003
R_L1_p_60_23 pixel_60 l1_psum_23 83333.333333333328
R_L1_p_61_23 pixel_61 l1_psum_23 50359.712230215831
R_L1_p_62_23 pixel_62 l1_psum_23 26923.076923076922
R_L1_p_63_23 pixel_63 l1_psum_23 1000000
E_TIA_L1_p_23 l1_pout_23 0 0 l1_psum_23 100000000
R_FB_L1_p_23 l1_pout_23 l1_psum_23 1000
R_L1_m_0_23 pixel_0 l1_msum_23 1000000
R_L1_m_1_23 pixel_1 l1_msum_23 66037.735849056597
R_L1_m_2_23 pixel_2 l1_msum_23 73684.210526315786
R_L1_m_3_23 pixel_3 l1_msum_23 29411.764705882353
R_L1_m_4_23 pixel_4 l1_msum_23 95890.410958904104
R_L1_m_5_23 pixel_5 l1_msum_23 26923.076923076922
R_L1_m_6_23 pixel_6 l1_msum_23 30837.004405286345
R_L1_m_7_23 pixel_7 l1_msum_23 241379.31034482759
R_L1_m_8_23 pixel_8 l1_msum_23 1000000
R_L1_m_9_23 pixel_9 l1_msum_23 95890.410958904104
R_L1_m_10_23 pixel_10 l1_msum_23 50359.712230215831
R_L1_m_11_23 pixel_11 l1_msum_23 1000000
R_L1_m_12_23 pixel_12 l1_msum_23 1000000
R_L1_m_13_23 pixel_13 l1_msum_23 1000000
R_L1_m_14_23 pixel_14 l1_msum_23 95890.410958904104
R_L1_m_15_23 pixel_15 l1_msum_23 66037.735849056597
R_L1_m_16_23 pixel_16 l1_msum_23 112903.22580645159
R_L1_m_17_23 pixel_17 l1_msum_23 95890.410958904104
R_L1_m_18_23 pixel_18 l1_msum_23 137254.90196078431
R_L1_m_19_23 pixel_19 l1_msum_23 1000000
R_L1_m_20_23 pixel_20 l1_msum_23 1000000
R_L1_m_21_23 pixel_21 l1_msum_23 1000000
R_L1_m_22_23 pixel_22 l1_msum_23 1000000
R_L1_m_23_23 pixel_23 l1_msum_23 34146.341463414632
R_L1_m_24_23 pixel_24 l1_msum_23 137254.90196078431
R_L1_m_25_23 pixel_25 l1_msum_23 95890.410958904104
R_L1_m_26_23 pixel_26 l1_msum_23 59829.059829059821
R_L1_m_27_23 pixel_27 l1_msum_23 46666.666666666664
R_L1_m_28_23 pixel_28 l1_msum_23 46666.666666666664
R_L1_m_29_23 pixel_29 l1_msum_23 241379.31034482759
R_L1_m_30_23 pixel_30 l1_msum_23 1000000
R_L1_m_31_23 pixel_31 l1_msum_23 36082.474226804123
R_L1_m_32_23 pixel_32 l1_msum_23 46666.666666666664
R_L1_m_33_23 pixel_33 l1_msum_23 1000000
R_L1_m_34_23 pixel_34 l1_msum_23 1000000
R_L1_m_35_23 pixel_35 l1_msum_23 73684.210526315786
R_L1_m_36_23 pixel_36 l1_msum_23 112903.22580645159
R_L1_m_37_23 pixel_37 l1_msum_23 175000.00000000003
R_L1_m_38_23 pixel_38 l1_msum_23 241379.31034482759
R_L1_m_39_23 pixel_39 l1_msum_23 1000000
R_L1_m_40_23 pixel_40 l1_msum_23 38251.366120218576
R_L1_m_41_23 pixel_41 l1_msum_23 73684.210526315786
R_L1_m_42_23 pixel_42 l1_msum_23 66037.735849056597
R_L1_m_43_23 pixel_43 l1_msum_23 137254.90196078431
R_L1_m_44_23 pixel_44 l1_msum_23 1000000
R_L1_m_45_23 pixel_45 l1_msum_23 59829.059829059821
R_L1_m_46_23 pixel_46 l1_msum_23 112903.22580645159
R_L1_m_47_23 pixel_47 l1_msum_23 1000000
R_L1_m_48_23 pixel_48 l1_msum_23 83333.333333333328
R_L1_m_49_23 pixel_49 l1_msum_23 1000000
R_L1_m_50_23 pixel_50 l1_msum_23 1000000
R_L1_m_51_23 pixel_51 l1_msum_23 1000000
R_L1_m_52_23 pixel_52 l1_msum_23 175000.00000000003
R_L1_m_53_23 pixel_53 l1_msum_23 137254.90196078431
R_L1_m_54_23 pixel_54 l1_msum_23 388888.88888888888
R_L1_m_55_23 pixel_55 l1_msum_23 1000000
R_L1_m_56_23 pixel_56 l1_msum_23 1000000
R_L1_m_57_23 pixel_57 l1_msum_23 1000000
R_L1_m_58_23 pixel_58 l1_msum_23 1000000
R_L1_m_59_23 pixel_59 l1_msum_23 1000000
R_L1_m_60_23 pixel_60 l1_msum_23 1000000
R_L1_m_61_23 pixel_61 l1_msum_23 1000000
R_L1_m_62_23 pixel_62 l1_msum_23 1000000
R_L1_m_63_23 pixel_63 l1_msum_23 1000000
E_TIA_L1_m_23 l1_mout_23 0 0 l1_msum_23 100000000
R_FB_L1_m_23 l1_mout_23 l1_msum_23 1000
B_NEURON_L1_23 hidden_23 0 V={0.01*max(((V(l1_mout_23)-V(l1_pout_23))/0.0030903275574088963+(0.32192584872245789)),0)}
R_L1_p_0_24 pixel_0 l1_psum_24 1000000
R_L1_p_1_24 pixel_1 l1_psum_24 1000000
R_L1_p_2_24 pixel_2 l1_psum_24 1000000
R_L1_p_3_24 pixel_3 l1_psum_24 1000000
R_L1_p_4_24 pixel_4 l1_psum_24 1000000
R_L1_p_5_24 pixel_5 l1_psum_24 1000000
R_L1_p_6_24 pixel_6 l1_psum_24 1000000
R_L1_p_7_24 pixel_7 l1_psum_24 1000000
R_L1_p_8_24 pixel_8 l1_psum_24 241379.31034482759
R_L1_p_9_24 pixel_9 l1_psum_24 95890.410958904104
R_L1_p_10_24 pixel_10 l1_psum_24 112903.22580645159
R_L1_p_11_24 pixel_11 l1_psum_24 388888.88888888888
R_L1_p_12_24 pixel_12 l1_psum_24 1000000
R_L1_p_13_24 pixel_13 l1_psum_24 112903.22580645159
R_L1_p_14_24 pixel_14 l1_psum_24 1000000
R_L1_p_15_24 pixel_15 l1_psum_24 1000000
R_L1_p_16_24 pixel_16 l1_psum_24 1000000
R_L1_p_17_24 pixel_17 l1_psum_24 73684.210526315786
R_L1_p_18_24 pixel_18 l1_psum_24 1000000
R_L1_p_19_24 pixel_19 l1_psum_24 1000000
R_L1_p_20_24 pixel_20 l1_psum_24 388888.88888888888
R_L1_p_21_24 pixel_21 l1_psum_24 29411.764705882353
R_L1_p_22_24 pixel_22 l1_psum_24 1000000
R_L1_p_23_24 pixel_23 l1_psum_24 1000000
R_L1_p_24_24 pixel_24 l1_psum_24 1000000
R_L1_p_25_24 pixel_25 l1_psum_24 1000000
R_L1_p_26_24 pixel_26 l1_psum_24 1000000
R_L1_p_27_24 pixel_27 l1_psum_24 1000000
R_L1_p_28_24 pixel_28 l1_psum_24 66037.735849056597
R_L1_p_29_24 pixel_29 l1_psum_24 388888.88888888888
R_L1_p_30_24 pixel_30 l1_psum_24 1000000
R_L1_p_31_24 pixel_31 l1_psum_24 1000000
R_L1_p_32_24 pixel_32 l1_psum_24 46666.666666666664
R_L1_p_33_24 pixel_33 l1_psum_24 1000000
R_L1_p_34_24 pixel_34 l1_psum_24 137254.90196078431
R_L1_p_35_24 pixel_35 l1_psum_24 83333.333333333328
R_L1_p_36_24 pixel_36 l1_psum_24 66037.735849056597
R_L1_p_37_24 pixel_37 l1_psum_24 1000000
R_L1_p_38_24 pixel_38 l1_psum_24 1000000
R_L1_p_39_24 pixel_39 l1_psum_24 54687.499999999993
R_L1_p_40_24 pixel_40 l1_psum_24 43478.260869565216
R_L1_p_41_24 pixel_41 l1_psum_24 73684.210526315786
R_L1_p_42_24 pixel_42 l1_psum_24 388888.88888888888
R_L1_p_43_24 pixel_43 l1_psum_24 1000000
R_L1_p_44_24 pixel_44 l1_psum_24 388888.88888888888
R_L1_p_45_24 pixel_45 l1_psum_24 83333.333333333328
R_L1_p_46_24 pixel_46 l1_psum_24 175000.00000000003
R_L1_p_47_24 pixel_47 l1_psum_24 1000000
R_L1_p_48_24 pixel_48 l1_psum_24 32407.407407407409
R_L1_p_49_24 pixel_49 l1_psum_24 54687.499999999993
R_L1_p_50_24 pixel_50 l1_psum_24 175000.00000000003
R_L1_p_51_24 pixel_51 l1_psum_24 1000000
R_L1_p_52_24 pixel_52 l1_psum_24 1000000
R_L1_p_53_24 pixel_53 l1_psum_24 54687.499999999993
R_L1_p_54_24 pixel_54 l1_psum_24 54687.499999999993
R_L1_p_55_24 pixel_55 l1_psum_24 241379.31034482759
R_L1_p_56_24 pixel_56 l1_psum_24 1000000
R_L1_p_57_24 pixel_57 l1_psum_24 1000000
R_L1_p_58_24 pixel_58 l1_psum_24 1000000
R_L1_p_59_24 pixel_59 l1_psum_24 1000000
R_L1_p_60_24 pixel_60 l1_psum_24 1000000
R_L1_p_61_24 pixel_61 l1_psum_24 1000000
R_L1_p_62_24 pixel_62 l1_psum_24 1000000
R_L1_p_63_24 pixel_63 l1_psum_24 175000.00000000003
E_TIA_L1_p_24 l1_pout_24 0 0 l1_psum_24 100000000
R_FB_L1_p_24 l1_pout_24 l1_psum_24 1000
R_L1_m_0_24 pixel_0 l1_msum_24 66037.735849056597
R_L1_m_1_24 pixel_1 l1_msum_24 388888.88888888888
R_L1_m_2_24 pixel_2 l1_msum_24 32407.407407407409
R_L1_m_3_24 pixel_3 l1_msum_24 50359.712230215831
R_L1_m_4_24 pixel_4 l1_msum_24 137254.90196078431
R_L1_m_5_24 pixel_5 l1_msum_24 32407.407407407409
R_L1_m_6_24 pixel_6 l1_msum_24 28112.449799196787
R_L1_m_7_24 pixel_7 l1_msum_24 1000000
R_L1_m_8_24 pixel_8 l1_msum_24 1000000
R_L1_m_9_24 pixel_9 l1_msum_24 1000000
R_L1_m_10_24 pixel_10 l1_msum_24 1000000
R_L1_m_11_24 pixel_11 l1_msum_24 1000000
R_L1_m_12_24 pixel_12 l1_msum_24 388888.88888888888
R_L1_m_13_24 pixel_13 l1_msum_24 1000000
R_L1_m_14_24 pixel_14 l1_msum_24 83333.333333333328
R_L1_m_15_24 pixel_15 l1_msum_24 66037.735849056597
R_L1_m_16_24 pixel_16 l1_msum_24 241379.31034482759
R_L1_m_17_24 pixel_17 l1_msum_24 1000000
R_L1_m_18_24 pixel_18 l1_msum_24 54687.499999999993
R_L1_m_19_24 pixel_19 l1_msum_24 95890.410958904104
R_L1_m_20_24 pixel_20 l1_msum_24 1000000
R_L1_m_21_24 pixel_21 l1_msum_24 1000000
R_L1_m_22_24 pixel_22 l1_msum_24 112903.22580645159
R_L1_m_23_24 pixel_23 l1_msum_24 40697.674418604649
R_L1_m_24_24 pixel_24 l1_msum_24 73684.210526315786
R_L1_m_25_24 pixel_25 l1_msum_24 95890.410958904104
R_L1_m_26_24 pixel_26 l1_msum_24 95890.410958904104
R_L1_m_27_24 pixel_27 l1_msum_24 50359.712230215831
R_L1_m_28_24 pixel_28 l1_msum_24 1000000
R_L1_m_29_24 pixel_29 l1_msum_24 1000000
R_L1_m_30_24 pixel_30 l1_msum_24 59829.059829059821
R_L1_m_31_24 pixel_31 l1_msum_24 83333.333333333328
R_L1_m_32_24 pixel_32 l1_msum_24 1000000
R_L1_m_33_24 pixel_33 l1_msum_24 388888.88888888888
R_L1_m_34_24 pixel_34 l1_msum_24 1000000
R_L1_m_35_24 pixel_35 l1_msum_24 1000000
R_L1_m_36_24 pixel_36 l1_msum_24 1000000
R_L1_m_37_24 pixel_37 l1_msum_24 112903.22580645159
R_L1_m_38_24 pixel_38 l1_msum_24 388888.88888888888
R_L1_m_39_24 pixel_39 l1_msum_24 1000000
R_L1_m_40_24 pixel_40 l1_msum_24 1000000
R_L1_m_41_24 pixel_41 l1_msum_24 1000000
R_L1_m_42_24 pixel_42 l1_msum_24 1000000
R_L1_m_43_24 pixel_43 l1_msum_24 137254.90196078431
R_L1_m_44_24 pixel_44 l1_msum_24 1000000
R_L1_m_45_24 pixel_45 l1_msum_24 1000000
R_L1_m_46_24 pixel_46 l1_msum_24 1000000
R_L1_m_47_24 pixel_47 l1_msum_24 241379.31034482759
R_L1_m_48_24 pixel_48 l1_msum_24 1000000
R_L1_m_49_24 pixel_49 l1_msum_24 1000000
R_L1_m_50_24 pixel_50 l1_msum_24 1000000
R_L1_m_51_24 pixel_51 l1_msum_24 175000.00000000003
R_L1_m_52_24 pixel_52 l1_msum_24 1000000
R_L1_m_53_24 pixel_53 l1_msum_24 1000000
R_L1_m_54_24 pixel_54 l1_msum_24 1000000
R_L1_m_55_24 pixel_55 l1_msum_24 1000000
R_L1_m_56_24 pixel_56 l1_msum_24 43478.260869565216
R_L1_m_57_24 pixel_57 l1_msum_24 95890.410958904104
R_L1_m_58_24 pixel_58 l1_msum_24 112903.22580645159
R_L1_m_59_24 pixel_59 l1_msum_24 112903.22580645159
R_L1_m_60_24 pixel_60 l1_msum_24 73684.210526315786
R_L1_m_61_24 pixel_61 l1_msum_24 34146.341463414632
R_L1_m_62_24 pixel_62 l1_msum_24 23026.315789473687
R_L1_m_63_24 pixel_63 l1_msum_24 1000000
E_TIA_L1_m_24 l1_mout_24 0 0 l1_msum_24 100000000
R_FB_L1_m_24 l1_mout_24 l1_msum_24 1000
B_NEURON_L1_24 hidden_24 0 V={0.01*max(((V(l1_mout_24)-V(l1_pout_24))/0.0030903275574088963+(0.099512577056884766)),0)}
R_L1_p_0_25 pixel_0 l1_psum_25 241379.31034482759
R_L1_p_1_25 pixel_1 l1_psum_25 1000000
R_L1_p_2_25 pixel_2 l1_psum_25 1000000
R_L1_p_3_25 pixel_3 l1_psum_25 1000000
R_L1_p_4_25 pixel_4 l1_psum_25 1000000
R_L1_p_5_25 pixel_5 l1_psum_25 1000000
R_L1_p_6_25 pixel_6 l1_psum_25 175000.00000000003
R_L1_p_7_25 pixel_7 l1_psum_25 1000000
R_L1_p_8_25 pixel_8 l1_psum_25 388888.88888888888
R_L1_p_9_25 pixel_9 l1_psum_25 1000000
R_L1_p_10_25 pixel_10 l1_psum_25 1000000
R_L1_p_11_25 pixel_11 l1_psum_25 1000000
R_L1_p_12_25 pixel_12 l1_psum_25 137254.90196078431
R_L1_p_13_25 pixel_13 l1_psum_25 83333.333333333328
R_L1_p_14_25 pixel_14 l1_psum_25 1000000
R_L1_p_15_25 pixel_15 l1_psum_25 1000000
R_L1_p_16_25 pixel_16 l1_psum_25 25830.258302583028
R_L1_p_17_25 pixel_17 l1_psum_25 24822.695035460994
R_L1_p_18_25 pixel_18 l1_psum_25 25830.258302583028
R_L1_p_19_25 pixel_19 l1_psum_25 83333.333333333328
R_L1_p_20_25 pixel_20 l1_psum_25 1000000
R_L1_p_21_25 pixel_21 l1_psum_25 38251.366120218576
R_L1_p_22_25 pixel_22 l1_psum_25 1000000
R_L1_p_23_25 pixel_23 l1_psum_25 1000000
R_L1_p_24_25 pixel_24 l1_psum_25 28112.449799196787
R_L1_p_25_25 pixel_25 l1_psum_25 1000000
R_L1_p_26_25 pixel_26 l1_psum_25 1000000
R_L1_p_27_25 pixel_27 l1_psum_25 1000000
R_L1_p_28_25 pixel_28 l1_psum_25 24822.695035460994
R_L1_p_29_25 pixel_29 l1_psum_25 137254.90196078431
R_L1_p_30_25 pixel_30 l1_psum_25 1000000
R_L1_p_31_25 pixel_31 l1_psum_25 1000000
R_L1_p_32_25 pixel_32 l1_psum_25 36082.474226804123
R_L1_p_33_25 pixel_33 l1_psum_25 1000000
R_L1_p_34_25 pixel_34 l1_psum_25 1000000
R_L1_p_35_25 pixel_35 l1_psum_25 83333.333333333328
R_L1_p_36_25 pixel_36 l1_psum_25 38251.366120218576
R_L1_p_37_25 pixel_37 l1_psum_25 1000000
R_L1_p_38_25 pixel_38 l1_psum_25 1000000
R_L1_p_39_25 pixel_39 l1_psum_25 1000000
R_L1_p_40_25 pixel_40 l1_psum_25 46666.666666666664
R_L1_p_41_25 pixel_41 l1_psum_25 1000000
R_L1_p_42_25 pixel_42 l1_psum_25 1000000
R_L1_p_43_25 pixel_43 l1_psum_25 1000000
R_L1_p_44_25 pixel_44 l1_psum_25 1000000
R_L1_p_45_25 pixel_45 l1_psum_25 1000000
R_L1_p_46_25 pixel_46 l1_psum_25 1000000
R_L1_p_47_25 pixel_47 l1_psum_25 66037.735849056597
R_L1_p_48_25 pixel_48 l1_psum_25 1000000
R_L1_p_49_25 pixel_49 l1_psum_25 59829.059829059821
R_L1_p_50_25 pixel_50 l1_psum_25 175000.00000000003
R_L1_p_51_25 pixel_51 l1_psum_25 1000000
R_L1_p_52_25 pixel_52 l1_psum_25 1000000
R_L1_p_53_25 pixel_53 l1_psum_25 1000000
R_L1_p_54_25 pixel_54 l1_psum_25 1000000
R_L1_p_55_25 pixel_55 l1_psum_25 388888.88888888888
R_L1_p_56_25 pixel_56 l1_psum_25 1000000
R_L1_p_57_25 pixel_57 l1_psum_25 25830.258302583028
R_L1_p_58_25 pixel_58 l1_psum_25 50359.712230215831
R_L1_p_59_25 pixel_59 l1_psum_25 175000.00000000003
R_L1_p_60_25 pixel_60 l1_psum_25 137254.90196078431
R_L1_p_61_25 pixel_61 l1_psum_25 175000.00000000003
R_L1_p_62_25 pixel_62 l1_psum_25 1000000
R_L1_p_63_25 pixel_63 l1_psum_25 1000000
E_TIA_L1_p_25 l1_pout_25 0 0 l1_psum_25 100000000
R_FB_L1_p_25 l1_pout_25 l1_psum_25 1000
R_L1_m_0_25 pixel_0 l1_msum_25 1000000
R_L1_m_1_25 pixel_1 l1_msum_25 83333.333333333328
R_L1_m_2_25 pixel_2 l1_msum_25 15659.955257270693
R_L1_m_3_25 pixel_3 l1_msum_25 24822.695035460994
R_L1_m_4_25 pixel_4 l1_msum_25 54687.499999999993
R_L1_m_5_25 pixel_5 l1_msum_25 59829.059829059821
R_L1_m_6_25 pixel_6 l1_msum_25 1000000
R_L1_m_7_25 pixel_7 l1_msum_25 43478.260869565216
R_L1_m_8_25 pixel_8 l1_msum_25 1000000
R_L1_m_9_25 pixel_9 l1_msum_25 28112.449799196787
R_L1_m_10_25 pixel_10 l1_msum_25 54687.499999999993
R_L1_m_11_25 pixel_11 l1_msum_25 95890.410958904104
R_L1_m_12_25 pixel_12 l1_msum_25 1000000
R_L1_m_13_25 pixel_13 l1_msum_25 1000000
R_L1_m_14_25 pixel_14 l1_msum_25 175000.00000000003
R_L1_m_15_25 pixel_15 l1_msum_25 1000000
R_L1_m_16_25 pixel_16 l1_msum_25 1000000
R_L1_m_17_25 pixel_17 l1_msum_25 1000000
R_L1_m_18_25 pixel_18 l1_msum_25 1000000
R_L1_m_19_25 pixel_19 l1_msum_25 1000000
R_L1_m_20_25 pixel_20 l1_msum_25 175000.00000000003
R_L1_m_21_25 pixel_21 l1_msum_25 1000000
R_L1_m_22_25 pixel_22 l1_msum_25 73684.210526315786
R_L1_m_23_25 pixel_23 l1_msum_25 43478.260869565216
R_L1_m_24_25 pixel_24 l1_msum_25 1000000
R_L1_m_25_25 pixel_25 l1_msum_25 112903.22580645159
R_L1_m_26_25 pixel_26 l1_msum_25 43478.260869565216
R_L1_m_27_25 pixel_27 l1_msum_25 50359.712230215831
R_L1_m_28_25 pixel_28 l1_msum_25 1000000
R_L1_m_29_25 pixel_29 l1_msum_25 1000000
R_L1_m_30_25 pixel_30 l1_msum_25 30837.004405286345
R_L1_m_31_25 pixel_31 l1_msum_25 30837.004405286345
R_L1_m_32_25 pixel_32 l1_msum_25 1000000
R_L1_m_33_25 pixel_33 l1_msum_25 20771.51335311573
R_L1_m_34_25 pixel_34 l1_msum_25 43478.260869565216
R_L1_m_35_25 pixel_35 l1_msum_25 1000000
R_L1_m_36_25 pixel_36 l1_msum_25 1000000
R_L1_m_37_25 pixel_37 l1_msum_25 25830.258302583028
R_L1_m_38_25 pixel_38 l1_msum_25 241379.31034482759
R_L1_m_39_25 pixel_39 l1_msum_25 95890.410958904104
R_L1_m_40_25 pixel_40 l1_msum_25 1000000
R_L1_m_41_25 pixel_41 l1_msum_25 50359.712230215831
R_L1_m_42_25 pixel_42 l1_msum_25 112903.22580645159
R_L1_m_43_25 pixel_43 l1_msum_25 1000000
R_L1_m_44_25 pixel_44 l1_msum_25 95890.410958904104
R_L1_m_45_25 pixel_45 l1_msum_25 241379.31034482759
R_L1_m_46_25 pixel_46 l1_msum_25 388888.88888888888
R_L1_m_47_25 pixel_47 l1_msum_25 1000000
R_L1_m_48_25 pixel_48 l1_msum_25 54687.499999999993
R_L1_m_49_25 pixel_49 l1_msum_25 1000000
R_L1_m_50_25 pixel_50 l1_msum_25 1000000
R_L1_m_51_25 pixel_51 l1_msum_25 95890.410958904104
R_L1_m_52_25 pixel_52 l1_msum_25 175000.00000000003
R_L1_m_53_25 pixel_53 l1_msum_25 175000.00000000003
R_L1_m_54_25 pixel_54 l1_msum_25 36082.474226804123
R_L1_m_55_25 pixel_55 l1_msum_25 1000000
R_L1_m_56_25 pixel_56 l1_msum_25 46666.666666666664
R_L1_m_57_25 pixel_57 l1_msum_25 1000000
R_L1_m_58_25 pixel_58 l1_msum_25 1000000
R_L1_m_59_25 pixel_59 l1_msum_25 1000000
R_L1_m_60_25 pixel_60 l1_msum_25 1000000
R_L1_m_61_25 pixel_61 l1_msum_25 1000000
R_L1_m_62_25 pixel_62 l1_msum_25 66037.735849056597
R_L1_m_63_25 pixel_63 l1_msum_25 1000000
E_TIA_L1_m_25 l1_mout_25 0 0 l1_msum_25 100000000
R_FB_L1_m_25 l1_mout_25 l1_msum_25 1000
B_NEURON_L1_25 hidden_25 0 V={0.01*max(((V(l1_mout_25)-V(l1_pout_25))/0.0030903275574088963+(0.2697213888168335)),0)}
R_L1_p_0_26 pixel_0 l1_psum_26 112903.22580645159
R_L1_p_1_26 pixel_1 l1_psum_26 66037.735849056597
R_L1_p_2_26 pixel_2 l1_psum_26 66037.735849056597
R_L1_p_3_26 pixel_3 l1_psum_26 43478.260869565216
R_L1_p_4_26 pixel_4 l1_psum_26 1000000
R_L1_p_5_26 pixel_5 l1_psum_26 1000000
R_L1_p_6_26 pixel_6 l1_psum_26 36082.474226804123
R_L1_p_7_26 pixel_7 l1_psum_26 95890.410958904104
R_L1_p_8_26 pixel_8 l1_psum_26 40697.674418604649
R_L1_p_9_26 pixel_9 l1_psum_26 73684.210526315786
R_L1_p_10_26 pixel_10 l1_psum_26 1000000
R_L1_p_11_26 pixel_11 l1_psum_26 175000.00000000003
R_L1_p_12_26 pixel_12 l1_psum_26 1000000
R_L1_p_13_26 pixel_13 l1_psum_26 1000000
R_L1_p_14_26 pixel_14 l1_psum_26 1000000
R_L1_p_15_26 pixel_15 l1_psum_26 54687.499999999993
R_L1_p_16_26 pixel_16 l1_psum_26 1000000
R_L1_p_17_26 pixel_17 l1_psum_26 1000000
R_L1_p_18_26 pixel_18 l1_psum_26 95890.410958904104
R_L1_p_19_26 pixel_19 l1_psum_26 36082.474226804123
R_L1_p_20_26 pixel_20 l1_psum_26 1000000
R_L1_p_21_26 pixel_21 l1_psum_26 1000000
R_L1_p_22_26 pixel_22 l1_psum_26 1000000
R_L1_p_23_26 pixel_23 l1_psum_26 73684.210526315786
R_L1_p_24_26 pixel_24 l1_psum_26 112903.22580645159
R_L1_p_25_26 pixel_25 l1_psum_26 43478.260869565216
R_L1_p_26_26 pixel_26 l1_psum_26 137254.90196078431
R_L1_p_27_26 pixel_27 l1_psum_26 73684.210526315786
R_L1_p_28_26 pixel_28 l1_psum_26 1000000
R_L1_p_29_26 pixel_29 l1_psum_26 1000000
R_L1_p_30_26 pixel_30 l1_psum_26 1000000
R_L1_p_31_26 pixel_31 l1_psum_26 66037.735849056597
R_L1_p_32_26 pixel_32 l1_psum_26 54687.499999999993
R_L1_p_33_26 pixel_33 l1_psum_26 1000000
R_L1_p_34_26 pixel_34 l1_psum_26 1000000
R_L1_p_35_26 pixel_35 l1_psum_26 175000.00000000003
R_L1_p_36_26 pixel_36 l1_psum_26 1000000
R_L1_p_37_26 pixel_37 l1_psum_26 66037.735849056597
R_L1_p_38_26 pixel_38 l1_psum_26 34146.341463414632
R_L1_p_39_26 pixel_39 l1_psum_26 1000000
R_L1_p_40_26 pixel_40 l1_psum_26 1000000
R_L1_p_41_26 pixel_41 l1_psum_26 1000000
R_L1_p_42_26 pixel_42 l1_psum_26 241379.31034482759
R_L1_p_43_26 pixel_43 l1_psum_26 95890.410958904104
R_L1_p_44_26 pixel_44 l1_psum_26 388888.88888888888
R_L1_p_45_26 pixel_45 l1_psum_26 388888.88888888888
R_L1_p_46_26 pixel_46 l1_psum_26 40697.674418604649
R_L1_p_47_26 pixel_47 l1_psum_26 1000000
R_L1_p_48_26 pixel_48 l1_psum_26 1000000
R_L1_p_49_26 pixel_49 l1_psum_26 1000000
R_L1_p_50_26 pixel_50 l1_psum_26 1000000
R_L1_p_51_26 pixel_51 l1_psum_26 388888.88888888888
R_L1_p_52_26 pixel_52 l1_psum_26 1000000
R_L1_p_53_26 pixel_53 l1_psum_26 388888.88888888888
R_L1_p_54_26 pixel_54 l1_psum_26 73684.210526315786
R_L1_p_55_26 pixel_55 l1_psum_26 1000000
R_L1_p_56_26 pixel_56 l1_psum_26 1000000
R_L1_p_57_26 pixel_57 l1_psum_26 1000000
R_L1_p_58_26 pixel_58 l1_psum_26 73684.210526315786
R_L1_p_59_26 pixel_59 l1_psum_26 83333.333333333328
R_L1_p_60_26 pixel_60 l1_psum_26 1000000
R_L1_p_61_26 pixel_61 l1_psum_26 1000000
R_L1_p_62_26 pixel_62 l1_psum_26 1000000
R_L1_p_63_26 pixel_63 l1_psum_26 1000000
E_TIA_L1_p_26 l1_pout_26 0 0 l1_psum_26 100000000
R_FB_L1_p_26 l1_pout_26 l1_psum_26 1000
R_L1_m_0_26 pixel_0 l1_msum_26 1000000
R_L1_m_1_26 pixel_1 l1_msum_26 1000000
R_L1_m_2_26 pixel_2 l1_msum_26 1000000
R_L1_m_3_26 pixel_3 l1_msum_26 1000000
R_L1_m_4_26 pixel_4 l1_msum_26 95890.410958904104
R_L1_m_5_26 pixel_5 l1_msum_26 73684.210526315786
R_L1_m_6_26 pixel_6 l1_msum_26 1000000
R_L1_m_7_26 pixel_7 l1_msum_26 1000000
R_L1_m_8_26 pixel_8 l1_msum_26 1000000
R_L1_m_9_26 pixel_9 l1_msum_26 1000000
R_L1_m_10_26 pixel_10 l1_msum_26 1000000
R_L1_m_11_26 pixel_11 l1_msum_26 1000000
R_L1_m_12_26 pixel_12 l1_msum_26 34146.341463414632
R_L1_m_13_26 pixel_13 l1_msum_26 10852.713178294574
R_L1_m_14_26 pixel_14 l1_msum_26 50359.712230215831
R_L1_m_15_26 pixel_15 l1_msum_26 1000000
R_L1_m_16_26 pixel_16 l1_msum_26 388888.88888888888
R_L1_m_17_26 pixel_17 l1_msum_26 112903.22580645159
R_L1_m_18_26 pixel_18 l1_msum_26 1000000
R_L1_m_19_26 pixel_19 l1_msum_26 1000000
R_L1_m_20_26 pixel_20 l1_msum_26 175000.00000000003
R_L1_m_21_26 pixel_21 l1_msum_26 20114.942528735632
R_L1_m_22_26 pixel_22 l1_msum_26 13944.223107569722
R_L1_m_23_26 pixel_23 l1_msum_26 1000000
R_L1_m_24_26 pixel_24 l1_msum_26 1000000
R_L1_m_25_26 pixel_25 l1_msum_26 1000000
R_L1_m_26_26 pixel_26 l1_msum_26 1000000
R_L1_m_27_26 pixel_27 l1_msum_26 1000000
R_L1_m_28_26 pixel_28 l1_msum_26 83333.333333333328
R_L1_m_29_26 pixel_29 l1_msum_26 137254.90196078431
R_L1_m_30_26 pixel_30 l1_msum_26 46666.666666666664
R_L1_m_31_26 pixel_31 l1_msum_26 1000000
R_L1_m_32_26 pixel_32 l1_msum_26 1000000
R_L1_m_33_26 pixel_33 l1_msum_26 59829.059829059821
R_L1_m_34_26 pixel_34 l1_msum_26 50359.712230215831
R_L1_m_35_26 pixel_35 l1_msum_26 1000000
R_L1_m_36_26 pixel_36 l1_msum_26 388888.88888888888
R_L1_m_37_26 pixel_37 l1_msum_26 1000000
R_L1_m_38_26 pixel_38 l1_msum_26 1000000
R_L1_m_39_26 pixel_39 l1_msum_26 38251.366120218576
R_L1_m_40_26 pixel_40 l1_msum_26 175000.00000000003
R_L1_m_41_26 pixel_41 l1_msum_26 1000000
R_L1_m_42_26 pixel_42 l1_msum_26 1000000
R_L1_m_43_26 pixel_43 l1_msum_26 1000000
R_L1_m_44_26 pixel_44 l1_msum_26 1000000
R_L1_m_45_26 pixel_45 l1_msum_26 1000000
R_L1_m_46_26 pixel_46 l1_msum_26 1000000
R_L1_m_47_26 pixel_47 l1_msum_26 388888.88888888888
R_L1_m_48_26 pixel_48 l1_msum_26 1000000
R_L1_m_49_26 pixel_49 l1_msum_26 46666.666666666664
R_L1_m_50_26 pixel_50 l1_msum_26 175000.00000000003
R_L1_m_51_26 pixel_51 l1_msum_26 1000000
R_L1_m_52_26 pixel_52 l1_msum_26 175000.00000000003
R_L1_m_53_26 pixel_53 l1_msum_26 1000000
R_L1_m_54_26 pixel_54 l1_msum_26 1000000
R_L1_m_55_26 pixel_55 l1_msum_26 95890.410958904104
R_L1_m_56_26 pixel_56 l1_msum_26 66037.735849056597
R_L1_m_57_26 pixel_57 l1_msum_26 66037.735849056597
R_L1_m_58_26 pixel_58 l1_msum_26 1000000
R_L1_m_59_26 pixel_59 l1_msum_26 1000000
R_L1_m_60_26 pixel_60 l1_msum_26 241379.31034482759
R_L1_m_61_26 pixel_61 l1_msum_26 112903.22580645159
R_L1_m_62_26 pixel_62 l1_msum_26 83333.333333333328
R_L1_m_63_26 pixel_63 l1_msum_26 112903.22580645159
E_TIA_L1_m_26 l1_mout_26 0 0 l1_msum_26 100000000
R_FB_L1_m_26 l1_mout_26 l1_msum_26 1000
B_NEURON_L1_26 hidden_26 0 V={0.01*max(((V(l1_mout_26)-V(l1_pout_26))/0.0030903275574088963+(0.295381098985672)),0)}
R_L1_p_0_27 pixel_0 l1_psum_27 95890.410958904104
R_L1_p_1_27 pixel_1 l1_psum_27 50359.712230215831
R_L1_p_2_27 pixel_2 l1_psum_27 28112.449799196787
R_L1_p_3_27 pixel_3 l1_psum_27 50359.712230215831
R_L1_p_4_27 pixel_4 l1_psum_27 83333.333333333328
R_L1_p_5_27 pixel_5 l1_psum_27 59829.059829059821
R_L1_p_6_27 pixel_6 l1_psum_27 43478.260869565216
R_L1_p_7_27 pixel_7 l1_psum_27 1000000
R_L1_p_8_27 pixel_8 l1_psum_27 1000000
R_L1_p_9_27 pixel_9 l1_psum_27 1000000
R_L1_p_10_27 pixel_10 l1_psum_27 1000000
R_L1_p_11_27 pixel_11 l1_psum_27 95890.410958904104
R_L1_p_12_27 pixel_12 l1_psum_27 241379.31034482759
R_L1_p_13_27 pixel_13 l1_psum_27 1000000
R_L1_p_14_27 pixel_14 l1_psum_27 1000000
R_L1_p_15_27 pixel_15 l1_psum_27 241379.31034482759
R_L1_p_16_27 pixel_16 l1_psum_27 59829.059829059821
R_L1_p_17_27 pixel_17 l1_psum_27 50359.712230215831
R_L1_p_18_27 pixel_18 l1_psum_27 95890.410958904104
R_L1_p_19_27 pixel_19 l1_psum_27 1000000
R_L1_p_20_27 pixel_20 l1_psum_27 73684.210526315786
R_L1_p_21_27 pixel_21 l1_psum_27 1000000
R_L1_p_22_27 pixel_22 l1_psum_27 1000000
R_L1_p_23_27 pixel_23 l1_psum_27 1000000
R_L1_p_24_27 pixel_24 l1_psum_27 40697.674418604649
R_L1_p_25_27 pixel_25 l1_psum_27 59829.059829059821
R_L1_p_26_27 pixel_26 l1_psum_27 1000000
R_L1_p_27_27 pixel_27 l1_psum_27 1000000
R_L1_p_28_27 pixel_28 l1_psum_27 1000000
R_L1_p_29_27 pixel_29 l1_psum_27 241379.31034482759
R_L1_p_30_27 pixel_30 l1_psum_27 38251.366120218576
R_L1_p_31_27 pixel_31 l1_psum_27 1000000
R_L1_p_32_27 pixel_32 l1_psum_27 1000000
R_L1_p_33_27 pixel_33 l1_psum_27 1000000
R_L1_p_34_27 pixel_34 l1_psum_27 137254.90196078431
R_L1_p_35_27 pixel_35 l1_psum_27 83333.333333333328
R_L1_p_36_27 pixel_36 l1_psum_27 54687.499999999993
R_L1_p_37_27 pixel_37 l1_psum_27 95890.410958904104
R_L1_p_38_27 pixel_38 l1_psum_27 1000000
R_L1_p_39_27 pixel_39 l1_psum_27 23890.784982935158
R_L1_p_40_27 pixel_40 l1_psum_27 1000000
R_L1_p_41_27 pixel_41 l1_psum_27 1000000
R_L1_p_42_27 pixel_42 l1_psum_27 95890.410958904104
R_L1_p_43_27 pixel_43 l1_psum_27 137254.90196078431
R_L1_p_44_27 pixel_44 l1_psum_27 1000000
R_L1_p_45_27 pixel_45 l1_psum_27 137254.90196078431
R_L1_p_46_27 pixel_46 l1_psum_27 1000000
R_L1_p_47_27 pixel_47 l1_psum_27 59829.059829059821
R_L1_p_48_27 pixel_48 l1_psum_27 1000000
R_L1_p_49_27 pixel_49 l1_psum_27 1000000
R_L1_p_50_27 pixel_50 l1_psum_27 1000000
R_L1_p_51_27 pixel_51 l1_psum_27 388888.88888888888
R_L1_p_52_27 pixel_52 l1_psum_27 1000000
R_L1_p_53_27 pixel_53 l1_psum_27 1000000
R_L1_p_54_27 pixel_54 l1_psum_27 1000000
R_L1_p_55_27 pixel_55 l1_psum_27 95890.410958904104
R_L1_p_56_27 pixel_56 l1_psum_27 1000000
R_L1_p_57_27 pixel_57 l1_psum_27 66037.735849056597
R_L1_p_58_27 pixel_58 l1_psum_27 83333.333333333328
R_L1_p_59_27 pixel_59 l1_psum_27 241379.31034482759
R_L1_p_60_27 pixel_60 l1_psum_27 66037.735849056597
R_L1_p_61_27 pixel_61 l1_psum_27 54687.499999999993
R_L1_p_62_27 pixel_62 l1_psum_27 1000000
R_L1_p_63_27 pixel_63 l1_psum_27 54687.499999999993
E_TIA_L1_p_27 l1_pout_27 0 0 l1_psum_27 100000000
R_FB_L1_p_27 l1_pout_27 l1_psum_27 1000
R_L1_m_0_27 pixel_0 l1_msum_27 1000000
R_L1_m_1_27 pixel_1 l1_msum_27 1000000
R_L1_m_2_27 pixel_2 l1_msum_27 1000000
R_L1_m_3_27 pixel_3 l1_msum_27 1000000
R_L1_m_4_27 pixel_4 l1_msum_27 1000000
R_L1_m_5_27 pixel_5 l1_msum_27 1000000
R_L1_m_6_27 pixel_6 l1_msum_27 1000000
R_L1_m_7_27 pixel_7 l1_msum_27 388888.88888888888
R_L1_m_8_27 pixel_8 l1_msum_27 54687.499999999993
R_L1_m_9_27 pixel_9 l1_msum_27 54687.499999999993
R_L1_m_10_27 pixel_10 l1_msum_27 1000000
R_L1_m_11_27 pixel_11 l1_msum_27 1000000
R_L1_m_12_27 pixel_12 l1_msum_27 1000000
R_L1_m_13_27 pixel_13 l1_msum_27 1000000
R_L1_m_14_27 pixel_14 l1_msum_27 73684.210526315786
R_L1_m_15_27 pixel_15 l1_msum_27 1000000
R_L1_m_16_27 pixel_16 l1_msum_27 1000000
R_L1_m_17_27 pixel_17 l1_msum_27 1000000
R_L1_m_18_27 pixel_18 l1_msum_27 1000000
R_L1_m_19_27 pixel_19 l1_msum_27 388888.88888888888
R_L1_m_20_27 pixel_20 l1_msum_27 1000000
R_L1_m_21_27 pixel_21 l1_msum_27 388888.88888888888
R_L1_m_22_27 pixel_22 l1_msum_27 137254.90196078431
R_L1_m_23_27 pixel_23 l1_msum_27 28112.449799196787
R_L1_m_24_27 pixel_24 l1_msum_27 1000000
R_L1_m_25_27 pixel_25 l1_msum_27 1000000
R_L1_m_26_27 pixel_26 l1_msum_27 1000000
R_L1_m_27_27 pixel_27 l1_msum_27 112903.22580645159
R_L1_m_28_27 pixel_28 l1_msum_27 66037.735849056597
R_L1_m_29_27 pixel_29 l1_msum_27 1000000
R_L1_m_30_27 pixel_30 l1_msum_27 1000000
R_L1_m_31_27 pixel_31 l1_msum_27 59829.059829059821
R_L1_m_32_27 pixel_32 l1_msum_27 59829.059829059821
R_L1_m_33_27 pixel_33 l1_msum_27 46666.666666666664
R_L1_m_34_27 pixel_34 l1_msum_27 1000000
R_L1_m_35_27 pixel_35 l1_msum_27 1000000
R_L1_m_36_27 pixel_36 l1_msum_27 1000000
R_L1_m_37_27 pixel_37 l1_msum_27 1000000
R_L1_m_38_27 pixel_38 l1_msum_27 241379.31034482759
R_L1_m_39_27 pixel_39 l1_msum_27 1000000
R_L1_m_40_27 pixel_40 l1_msum_27 38251.366120218576
R_L1_m_41_27 pixel_41 l1_msum_27 32407.407407407409
R_L1_m_42_27 pixel_42 l1_msum_27 1000000
R_L1_m_43_27 pixel_43 l1_msum_27 1000000
R_L1_m_44_27 pixel_44 l1_msum_27 137254.90196078431
R_L1_m_45_27 pixel_45 l1_msum_27 1000000
R_L1_m_46_27 pixel_46 l1_msum_27 95890.410958904104
R_L1_m_47_27 pixel_47 l1_msum_27 1000000
R_L1_m_48_27 pixel_48 l1_msum_27 66037.735849056597
R_L1_m_49_27 pixel_49 l1_msum_27 241379.31034482759
R_L1_m_50_27 pixel_50 l1_msum_27 241379.31034482759
R_L1_m_51_27 pixel_51 l1_msum_27 1000000
R_L1_m_52_27 pixel_52 l1_msum_27 54687.499999999993
R_L1_m_53_27 pixel_53 l1_msum_27 73684.210526315786
R_L1_m_54_27 pixel_54 l1_msum_27 137254.90196078431
R_L1_m_55_27 pixel_55 l1_msum_27 1000000
R_L1_m_56_27 pixel_56 l1_msum_27 175000.00000000003
R_L1_m_57_27 pixel_57 l1_msum_27 1000000
R_L1_m_58_27 pixel_58 l1_msum_27 1000000
R_L1_m_59_27 pixel_59 l1_msum_27 1000000
R_L1_m_60_27 pixel_60 l1_msum_27 1000000
R_L1_m_61_27 pixel_61 l1_msum_27 1000000
R_L1_m_62_27 pixel_62 l1_msum_27 175000.00000000003
R_L1_m_63_27 pixel_63 l1_msum_27 1000000
E_TIA_L1_m_27 l1_mout_27 0 0 l1_msum_27 100000000
R_FB_L1_m_27 l1_mout_27 l1_msum_27 1000
B_NEURON_L1_27 hidden_27 0 V={0.01*max(((V(l1_mout_27)-V(l1_pout_27))/0.0030903275574088963+(-0.0039182165637612343)),0)}
R_L1_p_0_28 pixel_0 l1_psum_28 1000000
R_L1_p_1_28 pixel_1 l1_psum_28 26923.076923076922
R_L1_p_2_28 pixel_2 l1_psum_28 54687.499999999993
R_L1_p_3_28 pixel_3 l1_psum_28 28112.449799196787
R_L1_p_4_28 pixel_4 l1_psum_28 66037.735849056597
R_L1_p_5_28 pixel_5 l1_psum_28 1000000
R_L1_p_6_28 pixel_6 l1_psum_28 66037.735849056597
R_L1_p_7_28 pixel_7 l1_psum_28 1000000
R_L1_p_8_28 pixel_8 l1_psum_28 1000000
R_L1_p_9_28 pixel_9 l1_psum_28 59829.059829059821
R_L1_p_10_28 pixel_10 l1_psum_28 1000000
R_L1_p_11_28 pixel_11 l1_psum_28 1000000
R_L1_p_12_28 pixel_12 l1_psum_28 1000000
R_L1_p_13_28 pixel_13 l1_psum_28 1000000
R_L1_p_14_28 pixel_14 l1_psum_28 59829.059829059821
R_L1_p_15_28 pixel_15 l1_psum_28 1000000
R_L1_p_16_28 pixel_16 l1_psum_28 1000000
R_L1_p_17_28 pixel_17 l1_psum_28 1000000
R_L1_p_18_28 pixel_18 l1_psum_28 1000000
R_L1_p_19_28 pixel_19 l1_psum_28 1000000
R_L1_p_20_28 pixel_20 l1_psum_28 1000000
R_L1_p_21_28 pixel_21 l1_psum_28 1000000
R_L1_p_22_28 pixel_22 l1_psum_28 1000000
R_L1_p_23_28 pixel_23 l1_psum_28 1000000
R_L1_p_24_28 pixel_24 l1_psum_28 1000000
R_L1_p_25_28 pixel_25 l1_psum_28 1000000
R_L1_p_26_28 pixel_26 l1_psum_28 66037.735849056597
R_L1_p_27_28 pixel_27 l1_psum_28 175000.00000000003
R_L1_p_28_28 pixel_28 l1_psum_28 38251.366120218576
R_L1_p_29_28 pixel_29 l1_psum_28 1000000
R_L1_p_30_28 pixel_30 l1_psum_28 1000000
R_L1_p_31_28 pixel_31 l1_psum_28 1000000
R_L1_p_32_28 pixel_32 l1_psum_28 1000000
R_L1_p_33_28 pixel_33 l1_psum_28 1000000
R_L1_p_34_28 pixel_34 l1_psum_28 137254.90196078431
R_L1_p_35_28 pixel_35 l1_psum_28 66037.735849056597
R_L1_p_36_28 pixel_36 l1_psum_28 50359.712230215831
R_L1_p_37_28 pixel_37 l1_psum_28 1000000
R_L1_p_38_28 pixel_38 l1_psum_28 54687.499999999993
R_L1_p_39_28 pixel_39 l1_psum_28 1000000
R_L1_p_40_28 pixel_40 l1_psum_28 1000000
R_L1_p_41_28 pixel_41 l1_psum_28 1000000
R_L1_p_42_28 pixel_42 l1_psum_28 1000000
R_L1_p_43_28 pixel_43 l1_psum_28 95890.410958904104
R_L1_p_44_28 pixel_44 l1_psum_28 1000000
R_L1_p_45_28 pixel_45 l1_psum_28 1000000
R_L1_p_46_28 pixel_46 l1_psum_28 1000000
R_L1_p_47_28 pixel_47 l1_psum_28 1000000
R_L1_p_48_28 pixel_48 l1_psum_28 1000000
R_L1_p_49_28 pixel_49 l1_psum_28 1000000
R_L1_p_50_28 pixel_50 l1_psum_28 1000000
R_L1_p_51_28 pixel_51 l1_psum_28 1000000
R_L1_p_52_28 pixel_52 l1_psum_28 1000000
R_L1_p_53_28 pixel_53 l1_psum_28 59829.059829059821
R_L1_p_54_28 pixel_54 l1_psum_28 1000000
R_L1_p_55_28 pixel_55 l1_psum_28 73684.210526315786
R_L1_p_56_28 pixel_56 l1_psum_28 1000000
R_L1_p_57_28 pixel_57 l1_psum_28 241379.31034482759
R_L1_p_58_28 pixel_58 l1_psum_28 83333.333333333328
R_L1_p_59_28 pixel_59 l1_psum_28 1000000
R_L1_p_60_28 pixel_60 l1_psum_28 1000000
R_L1_p_61_28 pixel_61 l1_psum_28 1000000
R_L1_p_62_28 pixel_62 l1_psum_28 95890.410958904104
R_L1_p_63_28 pixel_63 l1_psum_28 1000000
E_TIA_L1_p_28 l1_pout_28 0 0 l1_psum_28 100000000
R_FB_L1_p_28 l1_pout_28 l1_psum_28 1000
R_L1_m_0_28 pixel_0 l1_msum_28 95890.410958904104
R_L1_m_1_28 pixel_1 l1_msum_28 1000000
R_L1_m_2_28 pixel_2 l1_msum_28 1000000
R_L1_m_3_28 pixel_3 l1_msum_28 1000000
R_L1_m_4_28 pixel_4 l1_msum_28 1000000
R_L1_m_5_28 pixel_5 l1_msum_28 112903.22580645159
R_L1_m_6_28 pixel_6 l1_msum_28 1000000
R_L1_m_7_28 pixel_7 l1_msum_28 73684.210526315786
R_L1_m_8_28 pixel_8 l1_msum_28 73684.210526315786
R_L1_m_9_28 pixel_9 l1_msum_28 1000000
R_L1_m_10_28 pixel_10 l1_msum_28 241379.31034482759
R_L1_m_11_28 pixel_11 l1_msum_28 388888.88888888888
R_L1_m_12_28 pixel_12 l1_msum_28 36082.474226804123
R_L1_m_13_28 pixel_13 l1_msum_28 66037.735849056597
R_L1_m_14_28 pixel_14 l1_msum_28 1000000
R_L1_m_15_28 pixel_15 l1_msum_28 1000000
R_L1_m_16_28 pixel_16 l1_msum_28 20771.51335311573
R_L1_m_17_28 pixel_17 l1_msum_28 175000.00000000003
R_L1_m_18_28 pixel_18 l1_msum_28 50359.712230215831
R_L1_m_19_28 pixel_19 l1_msum_28 241379.31034482759
R_L1_m_20_28 pixel_20 l1_msum_28 137254.90196078431
R_L1_m_21_28 pixel_21 l1_msum_28 112903.22580645159
R_L1_m_22_28 pixel_22 l1_msum_28 36082.474226804123
R_L1_m_23_28 pixel_23 l1_msum_28 20771.51335311573
R_L1_m_24_28 pixel_24 l1_msum_28 46666.666666666664
R_L1_m_25_28 pixel_25 l1_msum_28 95890.410958904104
R_L1_m_26_28 pixel_26 l1_msum_28 1000000
R_L1_m_27_28 pixel_27 l1_msum_28 1000000
R_L1_m_28_28 pixel_28 l1_msum_28 1000000
R_L1_m_29_28 pixel_29 l1_msum_28 112903.22580645159
R_L1_m_30_28 pixel_30 l1_msum_28 95890.410958904104
R_L1_m_31_28 pixel_31 l1_msum_28 29411.764705882353
R_L1_m_32_28 pixel_32 l1_msum_28 66037.735849056597
R_L1_m_33_28 pixel_33 l1_msum_28 66037.735849056597
R_L1_m_34_28 pixel_34 l1_msum_28 1000000
R_L1_m_35_28 pixel_35 l1_msum_28 1000000
R_L1_m_36_28 pixel_36 l1_msum_28 1000000
R_L1_m_37_28 pixel_37 l1_msum_28 175000.00000000003
R_L1_m_38_28 pixel_38 l1_msum_28 1000000
R_L1_m_39_28 pixel_39 l1_msum_28 95890.410958904104
R_L1_m_40_28 pixel_40 l1_msum_28 54687.499999999993
R_L1_m_41_28 pixel_41 l1_msum_28 34146.341463414632
R_L1_m_42_28 pixel_42 l1_msum_28 137254.90196078431
R_L1_m_43_28 pixel_43 l1_msum_28 1000000
R_L1_m_44_28 pixel_44 l1_msum_28 175000.00000000003
R_L1_m_45_28 pixel_45 l1_msum_28 112903.22580645159
R_L1_m_46_28 pixel_46 l1_msum_28 30837.004405286345
R_L1_m_47_28 pixel_47 l1_msum_28 46666.666666666664
R_L1_m_48_28 pixel_48 l1_msum_28 22222.222222222223
R_L1_m_49_28 pixel_49 l1_msum_28 50359.712230215831
R_L1_m_50_28 pixel_50 l1_msum_28 112903.22580645159
R_L1_m_51_28 pixel_51 l1_msum_28 175000.00000000003
R_L1_m_52_28 pixel_52 l1_msum_28 66037.735849056597
R_L1_m_53_28 pixel_53 l1_msum_28 1000000
R_L1_m_54_28 pixel_54 l1_msum_28 175000.00000000003
R_L1_m_55_28 pixel_55 l1_msum_28 1000000
R_L1_m_56_28 pixel_56 l1_msum_28 95890.410958904104
R_L1_m_57_28 pixel_57 l1_msum_28 1000000
R_L1_m_58_28 pixel_58 l1_msum_28 1000000
R_L1_m_59_28 pixel_59 l1_msum_28 83333.333333333328
R_L1_m_60_28 pixel_60 l1_msum_28 28112.449799196787
R_L1_m_61_28 pixel_61 l1_msum_28 26923.076923076922
R_L1_m_62_28 pixel_62 l1_msum_28 1000000
R_L1_m_63_28 pixel_63 l1_msum_28 112903.22580645159
E_TIA_L1_m_28 l1_mout_28 0 0 l1_msum_28 100000000
R_FB_L1_m_28 l1_mout_28 l1_msum_28 1000
B_NEURON_L1_28 hidden_28 0 V={0.01*max(((V(l1_mout_28)-V(l1_pout_28))/0.0030903275574088963+(0.090932436287403107)),0)}
R_L1_p_0_29 pixel_0 l1_psum_29 1000000
R_L1_p_1_29 pixel_1 l1_psum_29 59829.059829059821
R_L1_p_2_29 pixel_2 l1_psum_29 22222.222222222223
R_L1_p_3_29 pixel_3 l1_psum_29 18372.70341207349
R_L1_p_4_29 pixel_4 l1_psum_29 29411.764705882353
R_L1_p_5_29 pixel_5 l1_psum_29 54687.499999999993
R_L1_p_6_29 pixel_6 l1_psum_29 241379.31034482759
R_L1_p_7_29 pixel_7 l1_psum_29 1000000
R_L1_p_8_29 pixel_8 l1_psum_29 1000000
R_L1_p_9_29 pixel_9 l1_psum_29 83333.333333333328
R_L1_p_10_29 pixel_10 l1_psum_29 137254.90196078431
R_L1_p_11_29 pixel_11 l1_psum_29 32407.407407407409
R_L1_p_12_29 pixel_12 l1_psum_29 25830.258302583028
R_L1_p_13_29 pixel_13 l1_psum_29 54687.499999999993
R_L1_p_14_29 pixel_14 l1_psum_29 1000000
R_L1_p_15_29 pixel_15 l1_psum_29 83333.333333333328
R_L1_p_16_29 pixel_16 l1_psum_29 1000000
R_L1_p_17_29 pixel_17 l1_psum_29 1000000
R_L1_p_18_29 pixel_18 l1_psum_29 1000000
R_L1_p_19_29 pixel_19 l1_psum_29 1000000
R_L1_p_20_29 pixel_20 l1_psum_29 112903.22580645159
R_L1_p_21_29 pixel_21 l1_psum_29 175000.00000000003
R_L1_p_22_29 pixel_22 l1_psum_29 112903.22580645159
R_L1_p_23_29 pixel_23 l1_psum_29 1000000
R_L1_p_24_29 pixel_24 l1_psum_29 1000000
R_L1_p_25_29 pixel_25 l1_psum_29 1000000
R_L1_p_26_29 pixel_26 l1_psum_29 1000000
R_L1_p_27_29 pixel_27 l1_psum_29 1000000
R_L1_p_28_29 pixel_28 l1_psum_29 54687.499999999993
R_L1_p_29_29 pixel_29 l1_psum_29 43478.260869565216
R_L1_p_30_29 pixel_30 l1_psum_29 1000000
R_L1_p_31_29 pixel_31 l1_psum_29 1000000
R_L1_p_32_29 pixel_32 l1_psum_29 66037.735849056597
R_L1_p_33_29 pixel_33 l1_psum_29 73684.210526315786
R_L1_p_34_29 pixel_34 l1_psum_29 1000000
R_L1_p_35_29 pixel_35 l1_psum_29 388888.88888888888
R_L1_p_36_29 pixel_36 l1_psum_29 1000000
R_L1_p_37_29 pixel_37 l1_psum_29 1000000
R_L1_p_38_29 pixel_38 l1_psum_29 1000000
R_L1_p_39_29 pixel_39 l1_psum_29 1000000
R_L1_p_40_29 pixel_40 l1_psum_29 1000000
R_L1_p_41_29 pixel_41 l1_psum_29 1000000
R_L1_p_42_29 pixel_42 l1_psum_29 112903.22580645159
R_L1_p_43_29 pixel_43 l1_psum_29 1000000
R_L1_p_44_29 pixel_44 l1_psum_29 1000000
R_L1_p_45_29 pixel_45 l1_psum_29 73684.210526315786
R_L1_p_46_29 pixel_46 l1_psum_29 388888.88888888888
R_L1_p_47_29 pixel_47 l1_psum_29 175000.00000000003
R_L1_p_48_29 pixel_48 l1_psum_29 34146.341463414632
R_L1_p_49_29 pixel_49 l1_psum_29 175000.00000000003
R_L1_p_50_29 pixel_50 l1_psum_29 54687.499999999993
R_L1_p_51_29 pixel_51 l1_psum_29 59829.059829059821
R_L1_p_52_29 pixel_52 l1_psum_29 40697.674418604649
R_L1_p_53_29 pixel_53 l1_psum_29 95890.410958904104
R_L1_p_54_29 pixel_54 l1_psum_29 73684.210526315786
R_L1_p_55_29 pixel_55 l1_psum_29 43478.260869565216
R_L1_p_56_29 pixel_56 l1_psum_29 1000000
R_L1_p_57_29 pixel_57 l1_psum_29 1000000
R_L1_p_58_29 pixel_58 l1_psum_29 95890.410958904104
R_L1_p_59_29 pixel_59 l1_psum_29 66037.735849056597
R_L1_p_60_29 pixel_60 l1_psum_29 36082.474226804123
R_L1_p_61_29 pixel_61 l1_psum_29 83333.333333333328
R_L1_p_62_29 pixel_62 l1_psum_29 32407.407407407409
R_L1_p_63_29 pixel_63 l1_psum_29 43478.260869565216
E_TIA_L1_p_29 l1_pout_29 0 0 l1_psum_29 100000000
R_FB_L1_p_29 l1_pout_29 l1_psum_29 1000
R_L1_m_0_29 pixel_0 l1_msum_29 1000000
R_L1_m_1_29 pixel_1 l1_msum_29 1000000
R_L1_m_2_29 pixel_2 l1_msum_29 1000000
R_L1_m_3_29 pixel_3 l1_msum_29 1000000
R_L1_m_4_29 pixel_4 l1_msum_29 1000000
R_L1_m_5_29 pixel_5 l1_msum_29 1000000
R_L1_m_6_29 pixel_6 l1_msum_29 1000000
R_L1_m_7_29 pixel_7 l1_msum_29 388888.88888888888
R_L1_m_8_29 pixel_8 l1_msum_29 175000.00000000003
R_L1_m_9_29 pixel_9 l1_msum_29 1000000
R_L1_m_10_29 pixel_10 l1_msum_29 1000000
R_L1_m_11_29 pixel_11 l1_msum_29 1000000
R_L1_m_12_29 pixel_12 l1_msum_29 1000000
R_L1_m_13_29 pixel_13 l1_msum_29 1000000
R_L1_m_14_29 pixel_14 l1_msum_29 1000000
R_L1_m_15_29 pixel_15 l1_msum_29 1000000
R_L1_m_16_29 pixel_16 l1_msum_29 66037.735849056597
R_L1_m_17_29 pixel_17 l1_msum_29 112903.22580645159
R_L1_m_18_29 pixel_18 l1_msum_29 241379.31034482759
R_L1_m_19_29 pixel_19 l1_msum_29 59829.059829059821
R_L1_m_20_29 pixel_20 l1_msum_29 1000000
R_L1_m_21_29 pixel_21 l1_msum_29 1000000
R_L1_m_22_29 pixel_22 l1_msum_29 1000000
R_L1_m_23_29 pixel_23 l1_msum_29 241379.31034482759
R_L1_m_24_29 pixel_24 l1_msum_29 388888.88888888888
R_L1_m_25_29 pixel_25 l1_msum_29 73684.210526315786
R_L1_m_26_29 pixel_26 l1_msum_29 66037.735849056597
R_L1_m_27_29 pixel_27 l1_msum_29 54687.499999999993
R_L1_m_28_29 pixel_28 l1_msum_29 1000000
R_L1_m_29_29 pixel_29 l1_msum_29 1000000
R_L1_m_30_29 pixel_30 l1_msum_29 73684.210526315786
R_L1_m_31_29 pixel_31 l1_msum_29 175000.00000000003
R_L1_m_32_29 pixel_32 l1_msum_29 1000000
R_L1_m_33_29 pixel_33 l1_msum_29 1000000
R_L1_m_34_29 pixel_34 l1_msum_29 95890.410958904104
R_L1_m_35_29 pixel_35 l1_msum_29 1000000
R_L1_m_36_29 pixel_36 l1_msum_29 1000000
R_L1_m_37_29 pixel_37 l1_msum_29 46666.666666666664
R_L1_m_38_29 pixel_38 l1_msum_29 26923.076923076922
R_L1_m_39_29 pixel_39 l1_msum_29 241379.31034482759
R_L1_m_40_29 pixel_40 l1_msum_29 95890.410958904104
R_L1_m_41_29 pixel_41 l1_msum_29 1000000
R_L1_m_42_29 pixel_42 l1_msum_29 1000000
R_L1_m_43_29 pixel_43 l1_msum_29 50359.712230215831
R_L1_m_44_29 pixel_44 l1_msum_29 66037.735849056597
R_L1_m_45_29 pixel_45 l1_msum_29 1000000
R_L1_m_46_29 pixel_46 l1_msum_29 1000000
R_L1_m_47_29 pixel_47 l1_msum_29 1000000
R_L1_m_48_29 pixel_48 l1_msum_29 1000000
R_L1_m_49_29 pixel_49 l1_msum_29 1000000
R_L1_m_50_29 pixel_50 l1_msum_29 1000000
R_L1_m_51_29 pixel_51 l1_msum_29 1000000
R_L1_m_52_29 pixel_52 l1_msum_29 1000000
R_L1_m_53_29 pixel_53 l1_msum_29 1000000
R_L1_m_54_29 pixel_54 l1_msum_29 1000000
R_L1_m_55_29 pixel_55 l1_msum_29 1000000
R_L1_m_56_29 pixel_56 l1_msum_29 34146.341463414632
R_L1_m_57_29 pixel_57 l1_msum_29 73684.210526315786
R_L1_m_58_29 pixel_58 l1_msum_29 1000000
R_L1_m_59_29 pixel_59 l1_msum_29 1000000
R_L1_m_60_29 pixel_60 l1_msum_29 1000000
R_L1_m_61_29 pixel_61 l1_msum_29 1000000
R_L1_m_62_29 pixel_62 l1_msum_29 1000000
R_L1_m_63_29 pixel_63 l1_msum_29 1000000
E_TIA_L1_m_29 l1_mout_29 0 0 l1_msum_29 100000000
R_FB_L1_m_29 l1_mout_29 l1_msum_29 1000
B_NEURON_L1_29 hidden_29 0 V={0.01*max(((V(l1_mout_29)-V(l1_pout_29))/0.0030903275574088963+(-0.1313222348690033)),0)}
R_L1_p_0_30 pixel_0 l1_psum_30 1000000
R_L1_p_1_30 pixel_1 l1_psum_30 1000000
R_L1_p_2_30 pixel_2 l1_psum_30 1000000
R_L1_p_3_30 pixel_3 l1_psum_30 1000000
R_L1_p_4_30 pixel_4 l1_psum_30 1000000
R_L1_p_5_30 pixel_5 l1_psum_30 1000000
R_L1_p_6_30 pixel_6 l1_psum_30 1000000
R_L1_p_7_30 pixel_7 l1_psum_30 1000000
R_L1_p_8_30 pixel_8 l1_psum_30 66037.735849056597
R_L1_p_9_30 pixel_9 l1_psum_30 1000000
R_L1_p_10_30 pixel_10 l1_psum_30 1000000
R_L1_p_11_30 pixel_11 l1_psum_30 1000000
R_L1_p_12_30 pixel_12 l1_psum_30 1000000
R_L1_p_13_30 pixel_13 l1_psum_30 1000000
R_L1_p_14_30 pixel_14 l1_psum_30 137254.90196078431
R_L1_p_15_30 pixel_15 l1_psum_30 1000000
R_L1_p_16_30 pixel_16 l1_psum_30 26923.076923076922
R_L1_p_17_30 pixel_17 l1_psum_30 59829.059829059821
R_L1_p_18_30 pixel_18 l1_psum_30 83333.333333333328
R_L1_p_19_30 pixel_19 l1_psum_30 137254.90196078431
R_L1_p_20_30 pixel_20 l1_psum_30 241379.31034482759
R_L1_p_21_30 pixel_21 l1_psum_30 388888.88888888888
R_L1_p_22_30 pixel_22 l1_psum_30 66037.735849056597
R_L1_p_23_30 pixel_23 l1_psum_30 175000.00000000003
R_L1_p_24_30 pixel_24 l1_psum_30 43478.260869565216
R_L1_p_25_30 pixel_25 l1_psum_30 388888.88888888888
R_L1_p_26_30 pixel_26 l1_psum_30 38251.366120218576
R_L1_p_27_30 pixel_27 l1_psum_30 54687.499999999993
R_L1_p_28_30 pixel_28 l1_psum_30 388888.88888888888
R_L1_p_29_30 pixel_29 l1_psum_30 83333.333333333328
R_L1_p_30_30 pixel_30 l1_psum_30 388888.88888888888
R_L1_p_31_30 pixel_31 l1_psum_30 1000000
R_L1_p_32_30 pixel_32 l1_psum_30 83333.333333333328
R_L1_p_33_30 pixel_33 l1_psum_30 1000000
R_L1_p_34_30 pixel_34 l1_psum_30 46666.666666666664
R_L1_p_35_30 pixel_35 l1_psum_30 1000000
R_L1_p_36_30 pixel_36 l1_psum_30 59829.059829059821
R_L1_p_37_30 pixel_37 l1_psum_30 73684.210526315786
R_L1_p_38_30 pixel_38 l1_psum_30 95890.410958904104
R_L1_p_39_30 pixel_39 l1_psum_30 1000000
R_L1_p_40_30 pixel_40 l1_psum_30 1000000
R_L1_p_41_30 pixel_41 l1_psum_30 1000000
R_L1_p_42_30 pixel_42 l1_psum_30 1000000
R_L1_p_43_30 pixel_43 l1_psum_30 1000000
R_L1_p_44_30 pixel_44 l1_psum_30 1000000
R_L1_p_45_30 pixel_45 l1_psum_30 1000000
R_L1_p_46_30 pixel_46 l1_psum_30 1000000
R_L1_p_47_30 pixel_47 l1_psum_30 1000000
R_L1_p_48_30 pixel_48 l1_psum_30 1000000
R_L1_p_49_30 pixel_49 l1_psum_30 1000000
R_L1_p_50_30 pixel_50 l1_psum_30 1000000
R_L1_p_51_30 pixel_51 l1_psum_30 137254.90196078431
R_L1_p_52_30 pixel_52 l1_psum_30 1000000
R_L1_p_53_30 pixel_53 l1_psum_30 1000000
R_L1_p_54_30 pixel_54 l1_psum_30 1000000
R_L1_p_55_30 pixel_55 l1_psum_30 1000000
R_L1_p_56_30 pixel_56 l1_psum_30 112903.22580645159
R_L1_p_57_30 pixel_57 l1_psum_30 73684.210526315786
R_L1_p_58_30 pixel_58 l1_psum_30 1000000
R_L1_p_59_30 pixel_59 l1_psum_30 1000000
R_L1_p_60_30 pixel_60 l1_psum_30 43478.260869565216
R_L1_p_61_30 pixel_61 l1_psum_30 175000.00000000003
R_L1_p_62_30 pixel_62 l1_psum_30 83333.333333333328
R_L1_p_63_30 pixel_63 l1_psum_30 1000000
E_TIA_L1_p_30 l1_pout_30 0 0 l1_psum_30 100000000
R_FB_L1_p_30 l1_pout_30 l1_psum_30 1000
R_L1_m_0_30 pixel_0 l1_msum_30 38251.366120218576
R_L1_m_1_30 pixel_1 l1_msum_30 26923.076923076922
R_L1_m_2_30 pixel_2 l1_msum_30 13645.22417153996
R_L1_m_3_30 pixel_3 l1_msum_30 14256.619144602852
R_L1_m_4_30 pixel_4 l1_msum_30 12323.943661971831
R_L1_m_5_30 pixel_5 l1_msum_30 43478.260869565216
R_L1_m_6_30 pixel_6 l1_msum_30 43478.260869565216
R_L1_m_7_30 pixel_7 l1_msum_30 66037.735849056597
R_L1_m_8_30 pixel_8 l1_msum_30 1000000
R_L1_m_9_30 pixel_9 l1_msum_30 241379.31034482759
R_L1_m_10_30 pixel_10 l1_msum_30 388888.88888888888
R_L1_m_11_30 pixel_11 l1_msum_30 59829.059829059821
R_L1_m_12_30 pixel_12 l1_msum_30 54687.499999999993
R_L1_m_13_30 pixel_13 l1_msum_30 137254.90196078431
R_L1_m_14_30 pixel_14 l1_msum_30 1000000
R_L1_m_15_30 pixel_15 l1_msum_30 1000000
R_L1_m_16_30 pixel_16 l1_msum_30 1000000
R_L1_m_17_30 pixel_17 l1_msum_30 1000000
R_L1_m_18_30 pixel_18 l1_msum_30 1000000
R_L1_m_19_30 pixel_19 l1_msum_30 1000000
R_L1_m_20_30 pixel_20 l1_msum_30 1000000
R_L1_m_21_30 pixel_21 l1_msum_30 1000000
R_L1_m_22_30 pixel_22 l1_msum_30 1000000
R_L1_m_23_30 pixel_23 l1_msum_30 1000000
R_L1_m_24_30 pixel_24 l1_msum_30 1000000
R_L1_m_25_30 pixel_25 l1_msum_30 1000000
R_L1_m_26_30 pixel_26 l1_msum_30 1000000
R_L1_m_27_30 pixel_27 l1_msum_30 1000000
R_L1_m_28_30 pixel_28 l1_msum_30 1000000
R_L1_m_29_30 pixel_29 l1_msum_30 1000000
R_L1_m_30_30 pixel_30 l1_msum_30 1000000
R_L1_m_31_30 pixel_31 l1_msum_30 66037.735849056597
R_L1_m_32_30 pixel_32 l1_msum_30 1000000
R_L1_m_33_30 pixel_33 l1_msum_30 1000000
R_L1_m_34_30 pixel_34 l1_msum_30 1000000
R_L1_m_35_30 pixel_35 l1_msum_30 54687.499999999993
R_L1_m_36_30 pixel_36 l1_msum_30 1000000
R_L1_m_37_30 pixel_37 l1_msum_30 1000000
R_L1_m_38_30 pixel_38 l1_msum_30 1000000
R_L1_m_39_30 pixel_39 l1_msum_30 36082.474226804123
R_L1_m_40_30 pixel_40 l1_msum_30 25830.258302583028
R_L1_m_41_30 pixel_41 l1_msum_30 43478.260869565216
R_L1_m_42_30 pixel_42 l1_msum_30 23026.315789473687
R_L1_m_43_30 pixel_43 l1_msum_30 46666.666666666664
R_L1_m_44_30 pixel_44 l1_msum_30 73684.210526315786
R_L1_m_45_30 pixel_45 l1_msum_30 36082.474226804123
R_L1_m_46_30 pixel_46 l1_msum_30 21472.39263803681
R_L1_m_47_30 pixel_47 l1_msum_30 29411.764705882353
R_L1_m_48_30 pixel_48 l1_msum_30 23026.315789473687
R_L1_m_49_30 pixel_49 l1_msum_30 50359.712230215831
R_L1_m_50_30 pixel_50 l1_msum_30 137254.90196078431
R_L1_m_51_30 pixel_51 l1_msum_30 1000000
R_L1_m_52_30 pixel_52 l1_msum_30 112903.22580645159
R_L1_m_53_30 pixel_53 l1_msum_30 46666.666666666664
R_L1_m_54_30 pixel_54 l1_msum_30 73684.210526315786
R_L1_m_55_30 pixel_55 l1_msum_30 83333.333333333328
R_L1_m_56_30 pixel_56 l1_msum_30 1000000
R_L1_m_57_30 pixel_57 l1_msum_30 1000000
R_L1_m_58_30 pixel_58 l1_msum_30 241379.31034482759
R_L1_m_59_30 pixel_59 l1_msum_30 388888.88888888888
R_L1_m_60_30 pixel_60 l1_msum_30 1000000
R_L1_m_61_30 pixel_61 l1_msum_30 1000000
R_L1_m_62_30 pixel_62 l1_msum_30 1000000
R_L1_m_63_30 pixel_63 l1_msum_30 66037.735849056597
E_TIA_L1_m_30 l1_mout_30 0 0 l1_msum_30 100000000
R_FB_L1_m_30 l1_mout_30 l1_msum_30 1000
B_NEURON_L1_30 hidden_30 0 V={0.01*max(((V(l1_mout_30)-V(l1_pout_30))/0.0030903275574088963+(0.2440313845872879)),0)}
R_L1_p_0_31 pixel_0 l1_psum_31 388888.88888888888
R_L1_p_1_31 pixel_1 l1_psum_31 46666.666666666664
R_L1_p_2_31 pixel_2 l1_psum_31 54687.499999999993
R_L1_p_3_31 pixel_3 l1_psum_31 50359.712230215831
R_L1_p_4_31 pixel_4 l1_psum_31 83333.333333333328
R_L1_p_5_31 pixel_5 l1_psum_31 1000000
R_L1_p_6_31 pixel_6 l1_psum_31 1000000
R_L1_p_7_31 pixel_7 l1_psum_31 32407.407407407409
R_L1_p_8_31 pixel_8 l1_psum_31 1000000
R_L1_p_9_31 pixel_9 l1_psum_31 1000000
R_L1_p_10_31 pixel_10 l1_psum_31 95890.410958904104
R_L1_p_11_31 pixel_11 l1_psum_31 46666.666666666664
R_L1_p_12_31 pixel_12 l1_psum_31 38251.366120218576
R_L1_p_13_31 pixel_13 l1_psum_31 388888.88888888888
R_L1_p_14_31 pixel_14 l1_psum_31 1000000
R_L1_p_15_31 pixel_15 l1_psum_31 59829.059829059821
R_L1_p_16_31 pixel_16 l1_psum_31 1000000
R_L1_p_17_31 pixel_17 l1_psum_31 1000000
R_L1_p_18_31 pixel_18 l1_psum_31 83333.333333333328
R_L1_p_19_31 pixel_19 l1_psum_31 1000000
R_L1_p_20_31 pixel_20 l1_psum_31 112903.22580645159
R_L1_p_21_31 pixel_21 l1_psum_31 1000000
R_L1_p_22_31 pixel_22 l1_psum_31 1000000
R_L1_p_23_31 pixel_23 l1_psum_31 29411.764705882353
R_L1_p_24_31 pixel_24 l1_psum_31 1000000
R_L1_p_25_31 pixel_25 l1_psum_31 1000000
R_L1_p_26_31 pixel_26 l1_psum_31 1000000
R_L1_p_27_31 pixel_27 l1_psum_31 83333.333333333328
R_L1_p_28_31 pixel_28 l1_psum_31 83333.333333333328
R_L1_p_29_31 pixel_29 l1_psum_31 1000000
R_L1_p_30_31 pixel_30 l1_psum_31 1000000
R_L1_p_31_31 pixel_31 l1_psum_31 36082.474226804123
R_L1_p_32_31 pixel_32 l1_psum_31 32407.407407407409
R_L1_p_33_31 pixel_33 l1_psum_31 1000000
R_L1_p_34_31 pixel_34 l1_psum_31 1000000
R_L1_p_35_31 pixel_35 l1_psum_31 38251.366120218576
R_L1_p_36_31 pixel_36 l1_psum_31 175000.00000000003
R_L1_p_37_31 pixel_37 l1_psum_31 241379.31034482759
R_L1_p_38_31 pixel_38 l1_psum_31 1000000
R_L1_p_39_31 pixel_39 l1_psum_31 40697.674418604649
R_L1_p_40_31 pixel_40 l1_psum_31 46666.666666666664
R_L1_p_41_31 pixel_41 l1_psum_31 46666.666666666664
R_L1_p_42_31 pixel_42 l1_psum_31 241379.31034482759
R_L1_p_43_31 pixel_43 l1_psum_31 1000000
R_L1_p_44_31 pixel_44 l1_psum_31 66037.735849056597
R_L1_p_45_31 pixel_45 l1_psum_31 175000.00000000003
R_L1_p_46_31 pixel_46 l1_psum_31 83333.333333333328
R_L1_p_47_31 pixel_47 l1_psum_31 66037.735849056597
R_L1_p_48_31 pixel_48 l1_psum_31 23026.315789473687
R_L1_p_49_31 pixel_49 l1_psum_31 1000000
R_L1_p_50_31 pixel_50 l1_psum_31 388888.88888888888
R_L1_p_51_31 pixel_51 l1_psum_31 388888.88888888888
R_L1_p_52_31 pixel_52 l1_psum_31 112903.22580645159
R_L1_p_53_31 pixel_53 l1_psum_31 137254.90196078431
R_L1_p_54_31 pixel_54 l1_psum_31 28112.449799196787
R_L1_p_55_31 pixel_55 l1_psum_31 66037.735849056597
R_L1_p_56_31 pixel_56 l1_psum_31 1000000
R_L1_p_57_31 pixel_57 l1_psum_31 175000.00000000003
R_L1_p_58_31 pixel_58 l1_psum_31 388888.88888888888
R_L1_p_59_31 pixel_59 l1_psum_31 112903.22580645159
R_L1_p_60_31 pixel_60 l1_psum_31 46666.666666666664
R_L1_p_61_31 pixel_61 l1_psum_31 34146.341463414632
R_L1_p_62_31 pixel_62 l1_psum_31 1000000
R_L1_p_63_31 pixel_63 l1_psum_31 175000.00000000003
E_TIA_L1_p_31 l1_pout_31 0 0 l1_psum_31 100000000
R_FB_L1_p_31 l1_pout_31 l1_psum_31 1000
R_L1_m_0_31 pixel_0 l1_msum_31 1000000
R_L1_m_1_31 pixel_1 l1_msum_31 1000000
R_L1_m_2_31 pixel_2 l1_msum_31 1000000
R_L1_m_3_31 pixel_3 l1_msum_31 1000000
R_L1_m_4_31 pixel_4 l1_msum_31 1000000
R_L1_m_5_31 pixel_5 l1_msum_31 241379.31034482759
R_L1_m_6_31 pixel_6 l1_msum_31 241379.31034482759
R_L1_m_7_31 pixel_7 l1_msum_31 1000000
R_L1_m_8_31 pixel_8 l1_msum_31 50359.712230215831
R_L1_m_9_31 pixel_9 l1_msum_31 95890.410958904104
R_L1_m_10_31 pixel_10 l1_msum_31 1000000
R_L1_m_11_31 pixel_11 l1_msum_31 1000000
R_L1_m_12_31 pixel_12 l1_msum_31 1000000
R_L1_m_13_31 pixel_13 l1_msum_31 1000000
R_L1_m_14_31 pixel_14 l1_msum_31 241379.31034482759
R_L1_m_15_31 pixel_15 l1_msum_31 1000000
R_L1_m_16_31 pixel_16 l1_msum_31 66037.735849056597
R_L1_m_17_31 pixel_17 l1_msum_31 112903.22580645159
R_L1_m_18_31 pixel_18 l1_msum_31 1000000
R_L1_m_19_31 pixel_19 l1_msum_31 241379.31034482759
R_L1_m_20_31 pixel_20 l1_msum_31 1000000
R_L1_m_21_31 pixel_21 l1_msum_31 83333.333333333328
R_L1_m_22_31 pixel_22 l1_msum_31 112903.22580645159
R_L1_m_23_31 pixel_23 l1_msum_31 1000000
R_L1_m_24_31 pixel_24 l1_msum_31 112903.22580645159
R_L1_m_25_31 pixel_25 l1_msum_31 388888.88888888888
R_L1_m_26_31 pixel_26 l1_msum_31 59829.059829059821
R_L1_m_27_31 pixel_27 l1_msum_31 1000000
R_L1_m_28_31 pixel_28 l1_msum_31 1000000
R_L1_m_29_31 pixel_29 l1_msum_31 112903.22580645159
R_L1_m_30_31 pixel_30 l1_msum_31 83333.333333333328
R_L1_m_31_31 pixel_31 l1_msum_31 1000000
R_L1_m_32_31 pixel_32 l1_msum_31 1000000
R_L1_m_33_31 pixel_33 l1_msum_31 388888.88888888888
R_L1_m_34_31 pixel_34 l1_msum_31 36082.474226804123
R_L1_m_35_31 pixel_35 l1_msum_31 1000000
R_L1_m_36_31 pixel_36 l1_msum_31 1000000
R_L1_m_37_31 pixel_37 l1_msum_31 1000000
R_L1_m_38_31 pixel_38 l1_msum_31 95890.410958904104
R_L1_m_39_31 pixel_39 l1_msum_31 1000000
R_L1_m_40_31 pixel_40 l1_msum_31 1000000
R_L1_m_41_31 pixel_41 l1_msum_31 1000000
R_L1_m_42_31 pixel_42 l1_msum_31 1000000
R_L1_m_43_31 pixel_43 l1_msum_31 83333.333333333328
R_L1_m_44_31 pixel_44 l1_msum_31 1000000
R_L1_m_45_31 pixel_45 l1_msum_31 1000000
R_L1_m_46_31 pixel_46 l1_msum_31 1000000
R_L1_m_47_31 pixel_47 l1_msum_31 1000000
R_L1_m_48_31 pixel_48 l1_msum_31 1000000
R_L1_m_49_31 pixel_49 l1_msum_31 175000.00000000003
R_L1_m_50_31 pixel_50 l1_msum_31 1000000
R_L1_m_51_31 pixel_51 l1_msum_31 1000000
R_L1_m_52_31 pixel_52 l1_msum_31 1000000
R_L1_m_53_31 pixel_53 l1_msum_31 1000000
R_L1_m_54_31 pixel_54 l1_msum_31 1000000
R_L1_m_55_31 pixel_55 l1_msum_31 1000000
R_L1_m_56_31 pixel_56 l1_msum_31 59829.059829059821
R_L1_m_57_31 pixel_57 l1_msum_31 1000000
R_L1_m_58_31 pixel_58 l1_msum_31 1000000
R_L1_m_59_31 pixel_59 l1_msum_31 1000000
R_L1_m_60_31 pixel_60 l1_msum_31 1000000
R_L1_m_61_31 pixel_61 l1_msum_31 1000000
R_L1_m_62_31 pixel_62 l1_msum_31 175000.00000000003
R_L1_m_63_31 pixel_63 l1_msum_31 1000000
E_TIA_L1_m_31 l1_mout_31 0 0 l1_msum_31 100000000
R_FB_L1_m_31 l1_mout_31 l1_msum_31 1000
B_NEURON_L1_31 hidden_31 0 V={0.01*max(((V(l1_mout_31)-V(l1_pout_31))/0.0030903275574088963+(0.41014376282691956)),0)}
R_L1_p_0_32 pixel_0 l1_psum_32 1000000
R_L1_p_1_32 pixel_1 l1_psum_32 32407.407407407409
R_L1_p_2_32 pixel_2 l1_psum_32 32407.407407407409
R_L1_p_3_32 pixel_3 l1_psum_32 66037.735849056597
R_L1_p_4_32 pixel_4 l1_psum_32 1000000
R_L1_p_5_32 pixel_5 l1_psum_32 175000.00000000003
R_L1_p_6_32 pixel_6 l1_psum_32 59829.059829059821
R_L1_p_7_32 pixel_7 l1_psum_32 1000000
R_L1_p_8_32 pixel_8 l1_psum_32 1000000
R_L1_p_9_32 pixel_9 l1_psum_32 1000000
R_L1_p_10_32 pixel_10 l1_psum_32 1000000
R_L1_p_11_32 pixel_11 l1_psum_32 241379.31034482759
R_L1_p_12_32 pixel_12 l1_psum_32 54687.499999999993
R_L1_p_13_32 pixel_13 l1_psum_32 46666.666666666664
R_L1_p_14_32 pixel_14 l1_psum_32 59829.059829059821
R_L1_p_15_32 pixel_15 l1_psum_32 54687.499999999993
R_L1_p_16_32 pixel_16 l1_psum_32 1000000
R_L1_p_17_32 pixel_17 l1_psum_32 1000000
R_L1_p_18_32 pixel_18 l1_psum_32 241379.31034482759
R_L1_p_19_32 pixel_19 l1_psum_32 388888.88888888888
R_L1_p_20_32 pixel_20 l1_psum_32 1000000
R_L1_p_21_32 pixel_21 l1_psum_32 1000000
R_L1_p_22_32 pixel_22 l1_psum_32 1000000
R_L1_p_23_32 pixel_23 l1_psum_32 1000000
R_L1_p_24_32 pixel_24 l1_psum_32 1000000
R_L1_p_25_32 pixel_25 l1_psum_32 95890.410958904104
R_L1_p_26_32 pixel_26 l1_psum_32 175000.00000000003
R_L1_p_27_32 pixel_27 l1_psum_32 241379.31034482759
R_L1_p_28_32 pixel_28 l1_psum_32 1000000
R_L1_p_29_32 pixel_29 l1_psum_32 1000000
R_L1_p_30_32 pixel_30 l1_psum_32 1000000
R_L1_p_31_32 pixel_31 l1_psum_32 1000000
R_L1_p_32_32 pixel_32 l1_psum_32 1000000
R_L1_p_33_32 pixel_33 l1_psum_32 241379.31034482759
R_L1_p_34_32 pixel_34 l1_psum_32 112903.22580645159
R_L1_p_35_32 pixel_35 l1_psum_32 50359.712230215831
R_L1_p_36_32 pixel_36 l1_psum_32 54687.499999999993
R_L1_p_37_32 pixel_37 l1_psum_32 83333.333333333328
R_L1_p_38_32 pixel_38 l1_psum_32 112903.22580645159
R_L1_p_39_32 pixel_39 l1_psum_32 95890.410958904104
R_L1_p_40_32 pixel_40 l1_psum_32 34146.341463414632
R_L1_p_41_32 pixel_41 l1_psum_32 1000000
R_L1_p_42_32 pixel_42 l1_psum_32 34146.341463414632
R_L1_p_43_32 pixel_43 l1_psum_32 73684.210526315786
R_L1_p_44_32 pixel_44 l1_psum_32 38251.366120218576
R_L1_p_45_32 pixel_45 l1_psum_32 1000000
R_L1_p_46_32 pixel_46 l1_psum_32 1000000
R_L1_p_47_32 pixel_47 l1_psum_32 1000000
R_L1_p_48_32 pixel_48 l1_psum_32 28112.449799196787
R_L1_p_49_32 pixel_49 l1_psum_32 1000000
R_L1_p_50_32 pixel_50 l1_psum_32 1000000
R_L1_p_51_32 pixel_51 l1_psum_32 50359.712230215831
R_L1_p_52_32 pixel_52 l1_psum_32 95890.410958904104
R_L1_p_53_32 pixel_53 l1_psum_32 112903.22580645159
R_L1_p_54_32 pixel_54 l1_psum_32 43478.260869565216
R_L1_p_55_32 pixel_55 l1_psum_32 241379.31034482759
R_L1_p_56_32 pixel_56 l1_psum_32 175000.00000000003
R_L1_p_57_32 pixel_57 l1_psum_32 137254.90196078431
R_L1_p_58_32 pixel_58 l1_psum_32 388888.88888888888
R_L1_p_59_32 pixel_59 l1_psum_32 1000000
R_L1_p_60_32 pixel_60 l1_psum_32 1000000
R_L1_p_61_32 pixel_61 l1_psum_32 1000000
R_L1_p_62_32 pixel_62 l1_psum_32 1000000
R_L1_p_63_32 pixel_63 l1_psum_32 73684.210526315786
E_TIA_L1_p_32 l1_pout_32 0 0 l1_psum_32 100000000
R_FB_L1_p_32 l1_pout_32 l1_psum_32 1000
R_L1_m_0_32 pixel_0 l1_msum_32 241379.31034482759
R_L1_m_1_32 pixel_1 l1_msum_32 1000000
R_L1_m_2_32 pixel_2 l1_msum_32 1000000
R_L1_m_3_32 pixel_3 l1_msum_32 1000000
R_L1_m_4_32 pixel_4 l1_msum_32 95890.410958904104
R_L1_m_5_32 pixel_5 l1_msum_32 1000000
R_L1_m_6_32 pixel_6 l1_msum_32 1000000
R_L1_m_7_32 pixel_7 l1_msum_32 59829.059829059821
R_L1_m_8_32 pixel_8 l1_msum_32 36082.474226804123
R_L1_m_9_32 pixel_9 l1_msum_32 137254.90196078431
R_L1_m_10_32 pixel_10 l1_msum_32 83333.333333333328
R_L1_m_11_32 pixel_11 l1_msum_32 1000000
R_L1_m_12_32 pixel_12 l1_msum_32 1000000
R_L1_m_13_32 pixel_13 l1_msum_32 1000000
R_L1_m_14_32 pixel_14 l1_msum_32 1000000
R_L1_m_15_32 pixel_15 l1_msum_32 1000000
R_L1_m_16_32 pixel_16 l1_msum_32 83333.333333333328
R_L1_m_17_32 pixel_17 l1_msum_32 175000.00000000003
R_L1_m_18_32 pixel_18 l1_msum_32 1000000
R_L1_m_19_32 pixel_19 l1_msum_32 1000000
R_L1_m_20_32 pixel_20 l1_msum_32 54687.499999999993
R_L1_m_21_32 pixel_21 l1_msum_32 66037.735849056597
R_L1_m_22_32 pixel_22 l1_msum_32 46666.666666666664
R_L1_m_23_32 pixel_23 l1_msum_32 54687.499999999993
R_L1_m_24_32 pixel_24 l1_msum_32 46666.666666666664
R_L1_m_25_32 pixel_25 l1_msum_32 1000000
R_L1_m_26_32 pixel_26 l1_msum_32 1000000
R_L1_m_27_32 pixel_27 l1_msum_32 1000000
R_L1_m_28_32 pixel_28 l1_msum_32 1000000
R_L1_m_29_32 pixel_29 l1_msum_32 388888.88888888888
R_L1_m_30_32 pixel_30 l1_msum_32 95890.410958904104
R_L1_m_31_32 pixel_31 l1_msum_32 83333.333333333328
R_L1_m_32_32 pixel_32 l1_msum_32 46666.666666666664
R_L1_m_33_32 pixel_33 l1_msum_32 1000000
R_L1_m_34_32 pixel_34 l1_msum_32 1000000
R_L1_m_35_32 pixel_35 l1_msum_32 1000000
R_L1_m_36_32 pixel_36 l1_msum_32 1000000
R_L1_m_37_32 pixel_37 l1_msum_32 1000000
R_L1_m_38_32 pixel_38 l1_msum_32 1000000
R_L1_m_39_32 pixel_39 l1_msum_32 1000000
R_L1_m_40_32 pixel_40 l1_msum_32 1000000
R_L1_m_41_32 pixel_41 l1_msum_32 1000000
R_L1_m_42_32 pixel_42 l1_msum_32 1000000
R_L1_m_43_32 pixel_43 l1_msum_32 1000000
R_L1_m_44_32 pixel_44 l1_msum_32 1000000
R_L1_m_45_32 pixel_45 l1_msum_32 388888.88888888888
R_L1_m_46_32 pixel_46 l1_msum_32 95890.410958904104
R_L1_m_47_32 pixel_47 l1_msum_32 388888.88888888888
R_L1_m_48_32 pixel_48 l1_msum_32 1000000
R_L1_m_49_32 pixel_49 l1_msum_32 30837.004405286345
R_L1_m_50_32 pixel_50 l1_msum_32 95890.410958904104
R_L1_m_51_32 pixel_51 l1_msum_32 1000000
R_L1_m_52_32 pixel_52 l1_msum_32 1000000
R_L1_m_53_32 pixel_53 l1_msum_32 1000000
R_L1_m_54_32 pixel_54 l1_msum_32 1000000
R_L1_m_55_32 pixel_55 l1_msum_32 1000000
R_L1_m_56_32 pixel_56 l1_msum_32 1000000
R_L1_m_57_32 pixel_57 l1_msum_32 1000000
R_L1_m_58_32 pixel_58 l1_msum_32 1000000
R_L1_m_59_32 pixel_59 l1_msum_32 137254.90196078431
R_L1_m_60_32 pixel_60 l1_msum_32 241379.31034482759
R_L1_m_61_32 pixel_61 l1_msum_32 73684.210526315786
R_L1_m_62_32 pixel_62 l1_msum_32 54687.499999999993
R_L1_m_63_32 pixel_63 l1_msum_32 1000000
E_TIA_L1_m_32 l1_mout_32 0 0 l1_msum_32 100000000
R_FB_L1_m_32 l1_mout_32 l1_msum_32 1000
B_NEURON_L1_32 hidden_32 0 V={0.01*max(((V(l1_mout_32)-V(l1_pout_32))/0.0030903275574088963+(0.16768139600753784)),0)}
R_L1_p_0_33 pixel_0 l1_psum_33 1000000
R_L1_p_1_33 pixel_1 l1_psum_33 1000000
R_L1_p_2_33 pixel_2 l1_psum_33 1000000
R_L1_p_3_33 pixel_3 l1_psum_33 1000000
R_L1_p_4_33 pixel_4 l1_psum_33 1000000
R_L1_p_5_33 pixel_5 l1_psum_33 1000000
R_L1_p_6_33 pixel_6 l1_psum_33 1000000
R_L1_p_7_33 pixel_7 l1_psum_33 1000000
R_L1_p_8_33 pixel_8 l1_psum_33 30837.004405286345
R_L1_p_9_33 pixel_9 l1_psum_33 1000000
R_L1_p_10_33 pixel_10 l1_psum_33 73684.210526315786
R_L1_p_11_33 pixel_11 l1_psum_33 50359.712230215831
R_L1_p_12_33 pixel_12 l1_psum_33 73684.210526315786
R_L1_p_13_33 pixel_13 l1_psum_33 1000000
R_L1_p_14_33 pixel_14 l1_psum_33 1000000
R_L1_p_15_33 pixel_15 l1_psum_33 1000000
R_L1_p_16_33 pixel_16 l1_psum_33 25830.258302583028
R_L1_p_17_33 pixel_17 l1_psum_33 30837.004405286345
R_L1_p_18_33 pixel_18 l1_psum_33 59829.059829059821
R_L1_p_19_33 pixel_19 l1_psum_33 59829.059829059821
R_L1_p_20_33 pixel_20 l1_psum_33 34146.341463414632
R_L1_p_21_33 pixel_21 l1_psum_33 36082.474226804123
R_L1_p_22_33 pixel_22 l1_psum_33 1000000
R_L1_p_23_33 pixel_23 l1_psum_33 1000000
R_L1_p_24_33 pixel_24 l1_psum_33 24822.695035460994
R_L1_p_25_33 pixel_25 l1_psum_33 1000000
R_L1_p_26_33 pixel_26 l1_psum_33 95890.410958904104
R_L1_p_27_33 pixel_27 l1_psum_33 54687.499999999993
R_L1_p_28_33 pixel_28 l1_psum_33 40697.674418604649
R_L1_p_29_33 pixel_29 l1_psum_33 83333.333333333328
R_L1_p_30_33 pixel_30 l1_psum_33 1000000
R_L1_p_31_33 pixel_31 l1_psum_33 1000000
R_L1_p_32_33 pixel_32 l1_psum_33 73684.210526315786
R_L1_p_33_33 pixel_33 l1_psum_33 1000000
R_L1_p_34_33 pixel_34 l1_psum_33 1000000
R_L1_p_35_33 pixel_35 l1_psum_33 1000000
R_L1_p_36_33 pixel_36 l1_psum_33 54687.499999999993
R_L1_p_37_33 pixel_37 l1_psum_33 43478.260869565216
R_L1_p_38_33 pixel_38 l1_psum_33 1000000
R_L1_p_39_33 pixel_39 l1_psum_33 1000000
R_L1_p_40_33 pixel_40 l1_psum_33 1000000
R_L1_p_41_33 pixel_41 l1_psum_33 1000000
R_L1_p_42_33 pixel_42 l1_psum_33 1000000
R_L1_p_43_33 pixel_43 l1_psum_33 1000000
R_L1_p_44_33 pixel_44 l1_psum_33 1000000
R_L1_p_45_33 pixel_45 l1_psum_33 1000000
R_L1_p_46_33 pixel_46 l1_psum_33 1000000
R_L1_p_47_33 pixel_47 l1_psum_33 1000000
R_L1_p_48_33 pixel_48 l1_psum_33 1000000
R_L1_p_49_33 pixel_49 l1_psum_33 1000000
R_L1_p_50_33 pixel_50 l1_psum_33 1000000
R_L1_p_51_33 pixel_51 l1_psum_33 1000000
R_L1_p_52_33 pixel_52 l1_psum_33 1000000
R_L1_p_53_33 pixel_53 l1_psum_33 1000000
R_L1_p_54_33 pixel_54 l1_psum_33 1000000
R_L1_p_55_33 pixel_55 l1_psum_33 1000000
R_L1_p_56_33 pixel_56 l1_psum_33 241379.31034482759
R_L1_p_57_33 pixel_57 l1_psum_33 14256.619144602852
R_L1_p_58_33 pixel_58 l1_psum_33 23026.315789473687
R_L1_p_59_33 pixel_59 l1_psum_33 34146.341463414632
R_L1_p_60_33 pixel_60 l1_psum_33 32407.407407407409
R_L1_p_61_33 pixel_61 l1_psum_33 26923.076923076922
R_L1_p_62_33 pixel_62 l1_psum_33 73684.210526315786
R_L1_p_63_33 pixel_63 l1_psum_33 1000000
E_TIA_L1_p_33 l1_pout_33 0 0 l1_psum_33 100000000
R_FB_L1_p_33 l1_pout_33 l1_psum_33 1000
R_L1_m_0_33 pixel_0 l1_msum_33 34146.341463414632
R_L1_m_1_33 pixel_1 l1_msum_33 83333.333333333328
R_L1_m_2_33 pixel_2 l1_msum_33 26923.076923076922
R_L1_m_3_33 pixel_3 l1_msum_33 34146.341463414632
R_L1_m_4_33 pixel_4 l1_msum_33 28112.449799196787
R_L1_m_5_33 pixel_5 l1_msum_33 43478.260869565216
R_L1_m_6_33 pixel_6 l1_msum_33 95890.410958904104
R_L1_m_7_33 pixel_7 l1_msum_33 40697.674418604649
R_L1_m_8_33 pixel_8 l1_msum_33 1000000
R_L1_m_9_33 pixel_9 l1_msum_33 175000.00000000003
R_L1_m_10_33 pixel_10 l1_msum_33 1000000
R_L1_m_11_33 pixel_11 l1_msum_33 1000000
R_L1_m_12_33 pixel_12 l1_msum_33 1000000
R_L1_m_13_33 pixel_13 l1_msum_33 175000.00000000003
R_L1_m_14_33 pixel_14 l1_msum_33 43478.260869565216
R_L1_m_15_33 pixel_15 l1_msum_33 95890.410958904104
R_L1_m_16_33 pixel_16 l1_msum_33 1000000
R_L1_m_17_33 pixel_17 l1_msum_33 1000000
R_L1_m_18_33 pixel_18 l1_msum_33 1000000
R_L1_m_19_33 pixel_19 l1_msum_33 1000000
R_L1_m_20_33 pixel_20 l1_msum_33 1000000
R_L1_m_21_33 pixel_21 l1_msum_33 1000000
R_L1_m_22_33 pixel_22 l1_msum_33 137254.90196078431
R_L1_m_23_33 pixel_23 l1_msum_33 95890.410958904104
R_L1_m_24_33 pixel_24 l1_msum_33 1000000
R_L1_m_25_33 pixel_25 l1_msum_33 241379.31034482759
R_L1_m_26_33 pixel_26 l1_msum_33 1000000
R_L1_m_27_33 pixel_27 l1_msum_33 1000000
R_L1_m_28_33 pixel_28 l1_msum_33 1000000
R_L1_m_29_33 pixel_29 l1_msum_33 1000000
R_L1_m_30_33 pixel_30 l1_msum_33 38251.366120218576
R_L1_m_31_33 pixel_31 l1_msum_33 241379.31034482759
R_L1_m_32_33 pixel_32 l1_msum_33 1000000
R_L1_m_33_33 pixel_33 l1_msum_33 83333.333333333328
R_L1_m_34_33 pixel_34 l1_msum_33 54687.499999999993
R_L1_m_35_33 pixel_35 l1_msum_33 95890.410958904104
R_L1_m_36_33 pixel_36 l1_msum_33 1000000
R_L1_m_37_33 pixel_37 l1_msum_33 1000000
R_L1_m_38_33 pixel_38 l1_msum_33 137254.90196078431
R_L1_m_39_33 pixel_39 l1_msum_33 30837.004405286345
R_L1_m_40_33 pixel_40 l1_msum_33 388888.88888888888
R_L1_m_41_33 pixel_41 l1_msum_33 175000.00000000003
R_L1_m_42_33 pixel_42 l1_msum_33 95890.410958904104
R_L1_m_43_33 pixel_43 l1_msum_33 83333.333333333328
R_L1_m_44_33 pixel_44 l1_msum_33 46666.666666666664
R_L1_m_45_33 pixel_45 l1_msum_33 175000.00000000003
R_L1_m_46_33 pixel_46 l1_msum_33 95890.410958904104
R_L1_m_47_33 pixel_47 l1_msum_33 26923.076923076922
R_L1_m_48_33 pixel_48 l1_msum_33 32407.407407407409
R_L1_m_49_33 pixel_49 l1_msum_33 241379.31034482759
R_L1_m_50_33 pixel_50 l1_msum_33 175000.00000000003
R_L1_m_51_33 pixel_51 l1_msum_33 241379.31034482759
R_L1_m_52_33 pixel_52 l1_msum_33 95890.410958904104
R_L1_m_53_33 pixel_53 l1_msum_33 112903.22580645159
R_L1_m_54_33 pixel_54 l1_msum_33 50359.712230215831
R_L1_m_55_33 pixel_55 l1_msum_33 66037.735849056597
R_L1_m_56_33 pixel_56 l1_msum_33 1000000
R_L1_m_57_33 pixel_57 l1_msum_33 1000000
R_L1_m_58_33 pixel_58 l1_msum_33 1000000
R_L1_m_59_33 pixel_59 l1_msum_33 1000000
R_L1_m_60_33 pixel_60 l1_msum_33 1000000
R_L1_m_61_33 pixel_61 l1_msum_33 1000000
R_L1_m_62_33 pixel_62 l1_msum_33 1000000
R_L1_m_63_33 pixel_63 l1_msum_33 66037.735849056597
E_TIA_L1_m_33 l1_mout_33 0 0 l1_msum_33 100000000
R_FB_L1_m_33 l1_mout_33 l1_msum_33 1000
B_NEURON_L1_33 hidden_33 0 V={0.01*max(((V(l1_mout_33)-V(l1_pout_33))/0.0030903275574088963+(-0.020151911303400993)),0)}
R_L1_p_0_34 pixel_0 l1_psum_34 1000000
R_L1_p_1_34 pixel_1 l1_psum_34 1000000
R_L1_p_2_34 pixel_2 l1_psum_34 1000000
R_L1_p_3_34 pixel_3 l1_psum_34 1000000
R_L1_p_4_34 pixel_4 l1_psum_34 1000000
R_L1_p_5_34 pixel_5 l1_psum_34 40697.674418604649
R_L1_p_6_34 pixel_6 l1_psum_34 54687.499999999993
R_L1_p_7_34 pixel_7 l1_psum_34 1000000
R_L1_p_8_34 pixel_8 l1_psum_34 1000000
R_L1_p_9_34 pixel_9 l1_psum_34 1000000
R_L1_p_10_34 pixel_10 l1_psum_34 1000000
R_L1_p_11_34 pixel_11 l1_psum_34 1000000
R_L1_p_12_34 pixel_12 l1_psum_34 1000000
R_L1_p_13_34 pixel_13 l1_psum_34 1000000
R_L1_p_14_34 pixel_14 l1_psum_34 66037.735849056597
R_L1_p_15_34 pixel_15 l1_psum_34 40697.674418604649
R_L1_p_16_34 pixel_16 l1_psum_34 1000000
R_L1_p_17_34 pixel_17 l1_psum_34 1000000
R_L1_p_18_34 pixel_18 l1_psum_34 1000000
R_L1_p_19_34 pixel_19 l1_psum_34 28112.449799196787
R_L1_p_20_34 pixel_20 l1_psum_34 175000.00000000003
R_L1_p_21_34 pixel_21 l1_psum_34 1000000
R_L1_p_22_34 pixel_22 l1_psum_34 137254.90196078431
R_L1_p_23_34 pixel_23 l1_psum_34 22222.222222222223
R_L1_p_24_34 pixel_24 l1_psum_34 1000000
R_L1_p_25_34 pixel_25 l1_psum_34 1000000
R_L1_p_26_34 pixel_26 l1_psum_34 388888.88888888888
R_L1_p_27_34 pixel_27 l1_psum_34 36082.474226804123
R_L1_p_28_34 pixel_28 l1_psum_34 137254.90196078431
R_L1_p_29_34 pixel_29 l1_psum_34 1000000
R_L1_p_30_34 pixel_30 l1_psum_34 1000000
R_L1_p_31_34 pixel_31 l1_psum_34 1000000
R_L1_p_32_34 pixel_32 l1_psum_34 1000000
R_L1_p_33_34 pixel_33 l1_psum_34 1000000
R_L1_p_34_34 pixel_34 l1_psum_34 1000000
R_L1_p_35_34 pixel_35 l1_psum_34 50359.712230215831
R_L1_p_36_34 pixel_36 l1_psum_34 54687.499999999993
R_L1_p_37_34 pixel_37 l1_psum_34 1000000
R_L1_p_38_34 pixel_38 l1_psum_34 1000000
R_L1_p_39_34 pixel_39 l1_psum_34 1000000
R_L1_p_40_34 pixel_40 l1_psum_34 1000000
R_L1_p_41_34 pixel_41 l1_psum_34 1000000
R_L1_p_42_34 pixel_42 l1_psum_34 1000000
R_L1_p_43_34 pixel_43 l1_psum_34 175000.00000000003
R_L1_p_44_34 pixel_44 l1_psum_34 59829.059829059821
R_L1_p_45_34 pixel_45 l1_psum_34 1000000
R_L1_p_46_34 pixel_46 l1_psum_34 1000000
R_L1_p_47_34 pixel_47 l1_psum_34 1000000
R_L1_p_48_34 pixel_48 l1_psum_34 1000000
R_L1_p_49_34 pixel_49 l1_psum_34 1000000
R_L1_p_50_34 pixel_50 l1_psum_34 175000.00000000003
R_L1_p_51_34 pixel_51 l1_psum_34 50359.712230215831
R_L1_p_52_34 pixel_52 l1_psum_34 112903.22580645159
R_L1_p_53_34 pixel_53 l1_psum_34 1000000
R_L1_p_54_34 pixel_54 l1_psum_34 1000000
R_L1_p_55_34 pixel_55 l1_psum_34 1000000
R_L1_p_56_34 pixel_56 l1_psum_34 34146.341463414632
R_L1_p_57_34 pixel_57 l1_psum_34 1000000
R_L1_p_58_34 pixel_58 l1_psum_34 1000000
R_L1_p_59_34 pixel_59 l1_psum_34 241379.31034482759
R_L1_p_60_34 pixel_60 l1_psum_34 1000000
R_L1_p_61_34 pixel_61 l1_psum_34 1000000
R_L1_p_62_34 pixel_62 l1_psum_34 1000000
R_L1_p_63_34 pixel_63 l1_psum_34 1000000
E_TIA_L1_p_34 l1_pout_34 0 0 l1_psum_34 100000000
R_FB_L1_p_34 l1_pout_34 l1_psum_34 1000
R_L1_m_0_34 pixel_0 l1_msum_34 241379.31034482759
R_L1_m_1_34 pixel_1 l1_msum_34 175000.00000000003
R_L1_m_2_34 pixel_2 l1_msum_34 19498.607242339833
R_L1_m_3_34 pixel_3 l1_msum_34 24822.695035460994
R_L1_m_4_34 pixel_4 l1_msum_34 34146.341463414632
R_L1_m_5_34 pixel_5 l1_msum_34 1000000
R_L1_m_6_34 pixel_6 l1_msum_34 1000000
R_L1_m_7_34 pixel_7 l1_msum_34 43478.260869565216
R_L1_m_8_34 pixel_8 l1_msum_34 59829.059829059821
R_L1_m_9_34 pixel_9 l1_msum_34 59829.059829059821
R_L1_m_10_34 pixel_10 l1_msum_34 24822.695035460994
R_L1_m_11_34 pixel_11 l1_msum_34 1000000
R_L1_m_12_34 pixel_12 l1_msum_34 388888.88888888888
R_L1_m_13_34 pixel_13 l1_msum_34 1000000
R_L1_m_14_34 pixel_14 l1_msum_34 1000000
R_L1_m_15_34 pixel_15 l1_msum_34 1000000
R_L1_m_16_34 pixel_16 l1_msum_34 17369.727047146403
R_L1_m_17_34 pixel_17 l1_msum_34 13084.112149532712
R_L1_m_18_34 pixel_18 l1_msum_34 46666.666666666664
R_L1_m_19_34 pixel_19 l1_msum_34 1000000
R_L1_m_20_34 pixel_20 l1_msum_34 1000000
R_L1_m_21_34 pixel_21 l1_msum_34 59829.059829059821
R_L1_m_22_34 pixel_22 l1_msum_34 1000000
R_L1_m_23_34 pixel_23 l1_msum_34 1000000
R_L1_m_24_34 pixel_24 l1_msum_34 30837.004405286345
R_L1_m_25_34 pixel_25 l1_msum_34 15283.842794759827
R_L1_m_26_34 pixel_26 l1_msum_34 1000000
R_L1_m_27_34 pixel_27 l1_msum_34 1000000
R_L1_m_28_34 pixel_28 l1_msum_34 1000000
R_L1_m_29_34 pixel_29 l1_msum_34 175000.00000000003
R_L1_m_30_34 pixel_30 l1_msum_34 241379.31034482759
R_L1_m_31_34 pixel_31 l1_msum_34 30837.004405286345
R_L1_m_32_34 pixel_32 l1_msum_34 66037.735849056597
R_L1_m_33_34 pixel_33 l1_msum_34 38251.366120218576
R_L1_m_34_34 pixel_34 l1_msum_34 59829.059829059821
R_L1_m_35_34 pixel_35 l1_msum_34 1000000
R_L1_m_36_34 pixel_36 l1_msum_34 1000000
R_L1_m_37_34 pixel_37 l1_msum_34 388888.88888888888
R_L1_m_38_34 pixel_38 l1_msum_34 38251.366120218576
R_L1_m_39_34 pixel_39 l1_msum_34 16055.045871559634
R_L1_m_40_34 pixel_40 l1_msum_34 18918.91891891892
R_L1_m_41_34 pixel_41 l1_msum_34 388888.88888888888
R_L1_m_42_34 pixel_42 l1_msum_34 95890.410958904104
R_L1_m_43_34 pixel_43 l1_msum_34 1000000
R_L1_m_44_34 pixel_44 l1_msum_34 1000000
R_L1_m_45_34 pixel_45 l1_msum_34 59829.059829059821
R_L1_m_46_34 pixel_46 l1_msum_34 19498.607242339833
R_L1_m_47_34 pixel_47 l1_msum_34 137254.90196078431
R_L1_m_48_34 pixel_48 l1_msum_34 30837.004405286345
R_L1_m_49_34 pixel_49 l1_msum_34 241379.31034482759
R_L1_m_50_34 pixel_50 l1_msum_34 1000000
R_L1_m_51_34 pixel_51 l1_msum_34 1000000
R_L1_m_52_34 pixel_52 l1_msum_34 1000000
R_L1_m_53_34 pixel_53 l1_msum_34 25830.258302583028
R_L1_m_54_34 pixel_54 l1_msum_34 20114.942528735632
R_L1_m_55_34 pixel_55 l1_msum_34 83333.333333333328
R_L1_m_56_34 pixel_56 l1_msum_34 1000000
R_L1_m_57_34 pixel_57 l1_msum_34 34146.341463414632
R_L1_m_58_34 pixel_58 l1_msum_34 112903.22580645159
R_L1_m_59_34 pixel_59 l1_msum_34 1000000
R_L1_m_60_34 pixel_60 l1_msum_34 241379.31034482759
R_L1_m_61_34 pixel_61 l1_msum_34 54687.499999999993
R_L1_m_62_34 pixel_62 l1_msum_34 241379.31034482759
R_L1_m_63_34 pixel_63 l1_msum_34 46666.666666666664
E_TIA_L1_m_34 l1_mout_34 0 0 l1_msum_34 100000000
R_FB_L1_m_34 l1_mout_34 l1_msum_34 1000
B_NEURON_L1_34 hidden_34 0 V={0.01*max(((V(l1_mout_34)-V(l1_pout_34))/0.0030903275574088963+(0.34474998712539673)),0)}
R_L1_p_0_35 pixel_0 l1_psum_35 73684.210526315786
R_L1_p_1_35 pixel_1 l1_psum_35 66037.735849056597
R_L1_p_2_35 pixel_2 l1_psum_35 83333.333333333328
R_L1_p_3_35 pixel_3 l1_psum_35 1000000
R_L1_p_4_35 pixel_4 l1_psum_35 1000000
R_L1_p_5_35 pixel_5 l1_psum_35 1000000
R_L1_p_6_35 pixel_6 l1_psum_35 40697.674418604649
R_L1_p_7_35 pixel_7 l1_psum_35 1000000
R_L1_p_8_35 pixel_8 l1_psum_35 46666.666666666664
R_L1_p_9_35 pixel_9 l1_psum_35 40697.674418604649
R_L1_p_10_35 pixel_10 l1_psum_35 175000.00000000003
R_L1_p_11_35 pixel_11 l1_psum_35 1000000
R_L1_p_12_35 pixel_12 l1_psum_35 1000000
R_L1_p_13_35 pixel_13 l1_psum_35 1000000
R_L1_p_14_35 pixel_14 l1_psum_35 36082.474226804123
R_L1_p_15_35 pixel_15 l1_psum_35 83333.333333333328
R_L1_p_16_35 pixel_16 l1_psum_35 1000000
R_L1_p_17_35 pixel_17 l1_psum_35 50359.712230215831
R_L1_p_18_35 pixel_18 l1_psum_35 36082.474226804123
R_L1_p_19_35 pixel_19 l1_psum_35 1000000
R_L1_p_20_35 pixel_20 l1_psum_35 28112.449799196787
R_L1_p_21_35 pixel_21 l1_psum_35 112903.22580645159
R_L1_p_22_35 pixel_22 l1_psum_35 1000000
R_L1_p_23_35 pixel_23 l1_psum_35 1000000
R_L1_p_24_35 pixel_24 l1_psum_35 1000000
R_L1_p_25_35 pixel_25 l1_psum_35 1000000
R_L1_p_26_35 pixel_26 l1_psum_35 1000000
R_L1_p_27_35 pixel_27 l1_psum_35 1000000
R_L1_p_28_35 pixel_28 l1_psum_35 83333.333333333328
R_L1_p_29_35 pixel_29 l1_psum_35 1000000
R_L1_p_30_35 pixel_30 l1_psum_35 1000000
R_L1_p_31_35 pixel_31 l1_psum_35 1000000
R_L1_p_32_35 pixel_32 l1_psum_35 1000000
R_L1_p_33_35 pixel_33 l1_psum_35 1000000
R_L1_p_34_35 pixel_34 l1_psum_35 1000000
R_L1_p_35_35 pixel_35 l1_psum_35 36082.474226804123
R_L1_p_36_35 pixel_36 l1_psum_35 83333.333333333328
R_L1_p_37_35 pixel_37 l1_psum_35 46666.666666666664
R_L1_p_38_35 pixel_38 l1_psum_35 1000000
R_L1_p_39_35 pixel_39 l1_psum_35 1000000
R_L1_p_40_35 pixel_40 l1_psum_35 1000000
R_L1_p_41_35 pixel_41 l1_psum_35 1000000
R_L1_p_42_35 pixel_42 l1_psum_35 137254.90196078431
R_L1_p_43_35 pixel_43 l1_psum_35 241379.31034482759
R_L1_p_44_35 pixel_44 l1_psum_35 1000000
R_L1_p_45_35 pixel_45 l1_psum_35 1000000
R_L1_p_46_35 pixel_46 l1_psum_35 1000000
R_L1_p_47_35 pixel_47 l1_psum_35 30837.004405286345
R_L1_p_48_35 pixel_48 l1_psum_35 1000000
R_L1_p_49_35 pixel_49 l1_psum_35 1000000
R_L1_p_50_35 pixel_50 l1_psum_35 137254.90196078431
R_L1_p_51_35 pixel_51 l1_psum_35 95890.410958904104
R_L1_p_52_35 pixel_52 l1_psum_35 112903.22580645159
R_L1_p_53_35 pixel_53 l1_psum_35 1000000
R_L1_p_54_35 pixel_54 l1_psum_35 50359.712230215831
R_L1_p_55_35 pixel_55 l1_psum_35 30837.004405286345
R_L1_p_56_35 pixel_56 l1_psum_35 66037.735849056597
R_L1_p_57_35 pixel_57 l1_psum_35 1000000
R_L1_p_58_35 pixel_58 l1_psum_35 1000000
R_L1_p_59_35 pixel_59 l1_psum_35 1000000
R_L1_p_60_35 pixel_60 l1_psum_35 1000000
R_L1_p_61_35 pixel_61 l1_psum_35 1000000
R_L1_p_62_35 pixel_62 l1_psum_35 1000000
R_L1_p_63_35 pixel_63 l1_psum_35 1000000
E_TIA_L1_p_35 l1_pout_35 0 0 l1_psum_35 100000000
R_FB_L1_p_35 l1_pout_35 l1_psum_35 1000
R_L1_m_0_35 pixel_0 l1_msum_35 1000000
R_L1_m_1_35 pixel_1 l1_msum_35 1000000
R_L1_m_2_35 pixel_2 l1_msum_35 1000000
R_L1_m_3_35 pixel_3 l1_msum_35 12567.324955116697
R_L1_m_4_35 pixel_4 l1_msum_35 10000
R_L1_m_5_35 pixel_5 l1_msum_35 241379.31034482759
R_L1_m_6_35 pixel_6 l1_msum_35 1000000
R_L1_m_7_35 pixel_7 l1_msum_35 83333.333333333328
R_L1_m_8_35 pixel_8 l1_msum_35 1000000
R_L1_m_9_35 pixel_9 l1_msum_35 1000000
R_L1_m_10_35 pixel_10 l1_msum_35 1000000
R_L1_m_11_35 pixel_11 l1_msum_35 14583.333333333334
R_L1_m_12_35 pixel_12 l1_msum_35 83333.333333333328
R_L1_m_13_35 pixel_13 l1_msum_35 1000000
R_L1_m_14_35 pixel_14 l1_msum_35 1000000
R_L1_m_15_35 pixel_15 l1_msum_35 1000000
R_L1_m_16_35 pixel_16 l1_msum_35 388888.88888888888
R_L1_m_17_35 pixel_17 l1_msum_35 1000000
R_L1_m_18_35 pixel_18 l1_msum_35 1000000
R_L1_m_19_35 pixel_19 l1_msum_35 14256.619144602852
R_L1_m_20_35 pixel_20 l1_msum_35 1000000
R_L1_m_21_35 pixel_21 l1_msum_35 1000000
R_L1_m_22_35 pixel_22 l1_msum_35 241379.31034482759
R_L1_m_23_35 pixel_23 l1_msum_35 20771.51335311573
R_L1_m_24_35 pixel_24 l1_msum_35 73684.210526315786
R_L1_m_25_35 pixel_25 l1_msum_35 1000000
R_L1_m_26_35 pixel_26 l1_msum_35 95890.410958904104
R_L1_m_27_35 pixel_27 l1_msum_35 241379.31034482759
R_L1_m_28_35 pixel_28 l1_msum_35 1000000
R_L1_m_29_35 pixel_29 l1_msum_35 137254.90196078431
R_L1_m_30_35 pixel_30 l1_msum_35 54687.499999999993
R_L1_m_31_35 pixel_31 l1_msum_35 13944.223107569722
R_L1_m_32_35 pixel_32 l1_msum_35 112903.22580645159
R_L1_m_33_35 pixel_33 l1_msum_35 23890.784982935158
R_L1_m_34_35 pixel_34 l1_msum_35 83333.333333333328
R_L1_m_35_35 pixel_35 l1_msum_35 1000000
R_L1_m_36_35 pixel_36 l1_msum_35 1000000
R_L1_m_37_35 pixel_37 l1_msum_35 1000000
R_L1_m_38_35 pixel_38 l1_msum_35 29411.764705882353
R_L1_m_39_35 pixel_39 l1_msum_35 25830.258302583028
R_L1_m_40_35 pixel_40 l1_msum_35 17857.142857142859
R_L1_m_41_35 pixel_41 l1_msum_35 38251.366120218576
R_L1_m_42_35 pixel_42 l1_msum_35 1000000
R_L1_m_43_35 pixel_43 l1_msum_35 1000000
R_L1_m_44_35 pixel_44 l1_msum_35 59829.059829059821
R_L1_m_45_35 pixel_45 l1_msum_35 43478.260869565216
R_L1_m_46_35 pixel_46 l1_msum_35 26923.076923076922
R_L1_m_47_35 pixel_47 l1_msum_35 1000000
R_L1_m_48_35 pixel_48 l1_msum_35 14583.333333333334
R_L1_m_49_35 pixel_49 l1_msum_35 1000000
R_L1_m_50_35 pixel_50 l1_msum_35 1000000
R_L1_m_51_35 pixel_51 l1_msum_35 1000000
R_L1_m_52_35 pixel_52 l1_msum_35 1000000
R_L1_m_53_35 pixel_53 l1_msum_35 83333.333333333328
R_L1_m_54_35 pixel_54 l1_msum_35 1000000
R_L1_m_55_35 pixel_55 l1_msum_35 1000000
R_L1_m_56_35 pixel_56 l1_msum_35 1000000
R_L1_m_57_35 pixel_57 l1_msum_35 73684.210526315786
R_L1_m_58_35 pixel_58 l1_msum_35 26923.076923076922
R_L1_m_59_35 pixel_59 l1_msum_35 50359.712230215831
R_L1_m_60_35 pixel_60 l1_msum_35 46666.666666666664
R_L1_m_61_35 pixel_61 l1_msum_35 66037.735849056597
R_L1_m_62_35 pixel_62 l1_msum_35 36082.474226804123
R_L1_m_63_35 pixel_63 l1_msum_35 95890.410958904104
E_TIA_L1_m_35 l1_mout_35 0 0 l1_msum_35 100000000
R_FB_L1_m_35 l1_mout_35 l1_msum_35 1000
B_NEURON_L1_35 hidden_35 0 V={0.01*max(((V(l1_mout_35)-V(l1_pout_35))/0.0030903275574088963+(0.056703038513660431)),0)}
R_L1_p_0_36 pixel_0 l1_psum_36 1000000
R_L1_p_1_36 pixel_1 l1_psum_36 1000000
R_L1_p_2_36 pixel_2 l1_psum_36 1000000
R_L1_p_3_36 pixel_3 l1_psum_36 1000000
R_L1_p_4_36 pixel_4 l1_psum_36 1000000
R_L1_p_5_36 pixel_5 l1_psum_36 1000000
R_L1_p_6_36 pixel_6 l1_psum_36 1000000
R_L1_p_7_36 pixel_7 l1_psum_36 175000.00000000003
R_L1_p_8_36 pixel_8 l1_psum_36 95890.410958904104
R_L1_p_9_36 pixel_9 l1_psum_36 241379.31034482759
R_L1_p_10_36 pixel_10 l1_psum_36 83333.333333333328
R_L1_p_11_36 pixel_11 l1_psum_36 388888.88888888888
R_L1_p_12_36 pixel_12 l1_psum_36 1000000
R_L1_p_13_36 pixel_13 l1_psum_36 1000000
R_L1_p_14_36 pixel_14 l1_psum_36 1000000
R_L1_p_15_36 pixel_15 l1_psum_36 112903.22580645159
R_L1_p_16_36 pixel_16 l1_psum_36 30837.004405286345
R_L1_p_17_36 pixel_17 l1_psum_36 50359.712230215831
R_L1_p_18_36 pixel_18 l1_psum_36 241379.31034482759
R_L1_p_19_36 pixel_19 l1_psum_36 43478.260869565216
R_L1_p_20_36 pixel_20 l1_psum_36 40697.674418604649
R_L1_p_21_36 pixel_21 l1_psum_36 1000000
R_L1_p_22_36 pixel_22 l1_psum_36 112903.22580645159
R_L1_p_23_36 pixel_23 l1_psum_36 1000000
R_L1_p_24_36 pixel_24 l1_psum_36 40697.674418604649
R_L1_p_25_36 pixel_25 l1_psum_36 137254.90196078431
R_L1_p_26_36 pixel_26 l1_psum_36 112903.22580645159
R_L1_p_27_36 pixel_27 l1_psum_36 54687.499999999993
R_L1_p_28_36 pixel_28 l1_psum_36 1000000
R_L1_p_29_36 pixel_29 l1_psum_36 1000000
R_L1_p_30_36 pixel_30 l1_psum_36 1000000
R_L1_p_31_36 pixel_31 l1_psum_36 46666.666666666664
R_L1_p_32_36 pixel_32 l1_psum_36 28112.449799196787
R_L1_p_33_36 pixel_33 l1_psum_36 1000000
R_L1_p_34_36 pixel_34 l1_psum_36 1000000
R_L1_p_35_36 pixel_35 l1_psum_36 1000000
R_L1_p_36_36 pixel_36 l1_psum_36 83333.333333333328
R_L1_p_37_36 pixel_37 l1_psum_36 83333.333333333328
R_L1_p_38_36 pixel_38 l1_psum_36 38251.366120218576
R_L1_p_39_36 pixel_39 l1_psum_36 26923.076923076922
R_L1_p_40_36 pixel_40 l1_psum_36 241379.31034482759
R_L1_p_41_36 pixel_41 l1_psum_36 1000000
R_L1_p_42_36 pixel_42 l1_psum_36 1000000
R_L1_p_43_36 pixel_43 l1_psum_36 1000000
R_L1_p_44_36 pixel_44 l1_psum_36 38251.366120218576
R_L1_p_45_36 pixel_45 l1_psum_36 1000000
R_L1_p_46_36 pixel_46 l1_psum_36 1000000
R_L1_p_47_36 pixel_47 l1_psum_36 1000000
R_L1_p_48_36 pixel_48 l1_psum_36 1000000
R_L1_p_49_36 pixel_49 l1_psum_36 1000000
R_L1_p_50_36 pixel_50 l1_psum_36 1000000
R_L1_p_51_36 pixel_51 l1_psum_36 1000000
R_L1_p_52_36 pixel_52 l1_psum_36 112903.22580645159
R_L1_p_53_36 pixel_53 l1_psum_36 175000.00000000003
R_L1_p_54_36 pixel_54 l1_psum_36 1000000
R_L1_p_55_36 pixel_55 l1_psum_36 50359.712230215831
R_L1_p_56_36 pixel_56 l1_psum_36 1000000
R_L1_p_57_36 pixel_57 l1_psum_36 1000000
R_L1_p_58_36 pixel_58 l1_psum_36 1000000
R_L1_p_59_36 pixel_59 l1_psum_36 1000000
R_L1_p_60_36 pixel_60 l1_psum_36 241379.31034482759
R_L1_p_61_36 pixel_61 l1_psum_36 95890.410958904104
R_L1_p_62_36 pixel_62 l1_psum_36 66037.735849056597
R_L1_p_63_36 pixel_63 l1_psum_36 1000000
E_TIA_L1_p_36 l1_pout_36 0 0 l1_psum_36 100000000
R_FB_L1_p_36 l1_pout_36 l1_psum_36 1000
R_L1_m_0_36 pixel_0 l1_msum_36 241379.31034482759
R_L1_m_1_36 pixel_1 l1_msum_36 54687.499999999993
R_L1_m_2_36 pixel_2 l1_msum_36 24822.695035460994
R_L1_m_3_36 pixel_3 l1_msum_36 23890.784982935158
R_L1_m_4_36 pixel_4 l1_msum_36 11041.009463722397
R_L1_m_5_36 pixel_5 l1_msum_36 21472.39263803681
R_L1_m_6_36 pixel_6 l1_msum_36 50359.712230215831
R_L1_m_7_36 pixel_7 l1_msum_36 1000000
R_L1_m_8_36 pixel_8 l1_msum_36 1000000
R_L1_m_9_36 pixel_9 l1_msum_36 1000000
R_L1_m_10_36 pixel_10 l1_msum_36 1000000
R_L1_m_11_36 pixel_11 l1_msum_36 1000000
R_L1_m_12_36 pixel_12 l1_msum_36 38251.366120218576
R_L1_m_13_36 pixel_13 l1_msum_36 18372.70341207349
R_L1_m_14_36 pixel_14 l1_msum_36 137254.90196078431
R_L1_m_15_36 pixel_15 l1_msum_36 1000000
R_L1_m_16_36 pixel_16 l1_msum_36 1000000
R_L1_m_17_36 pixel_17 l1_msum_36 1000000
R_L1_m_18_36 pixel_18 l1_msum_36 1000000
R_L1_m_19_36 pixel_19 l1_msum_36 1000000
R_L1_m_20_36 pixel_20 l1_msum_36 1000000
R_L1_m_21_36 pixel_21 l1_msum_36 22222.222222222223
R_L1_m_22_36 pixel_22 l1_msum_36 1000000
R_L1_m_23_36 pixel_23 l1_msum_36 43478.260869565216
R_L1_m_24_36 pixel_24 l1_msum_36 1000000
R_L1_m_25_36 pixel_25 l1_msum_36 1000000
R_L1_m_26_36 pixel_26 l1_msum_36 1000000
R_L1_m_27_36 pixel_27 l1_msum_36 1000000
R_L1_m_28_36 pixel_28 l1_msum_36 66037.735849056597
R_L1_m_29_36 pixel_29 l1_msum_36 175000.00000000003
R_L1_m_30_36 pixel_30 l1_msum_36 388888.88888888888
R_L1_m_31_36 pixel_31 l1_msum_36 1000000
R_L1_m_32_36 pixel_32 l1_msum_36 1000000
R_L1_m_33_36 pixel_33 l1_msum_36 175000.00000000003
R_L1_m_34_36 pixel_34 l1_msum_36 66037.735849056597
R_L1_m_35_36 pixel_35 l1_msum_36 29411.764705882353
R_L1_m_36_36 pixel_36 l1_msum_36 1000000
R_L1_m_37_36 pixel_37 l1_msum_36 1000000
R_L1_m_38_36 pixel_38 l1_msum_36 1000000
R_L1_m_39_36 pixel_39 l1_msum_36 1000000
R_L1_m_40_36 pixel_40 l1_msum_36 1000000
R_L1_m_41_36 pixel_41 l1_msum_36 83333.333333333328
R_L1_m_42_36 pixel_42 l1_msum_36 17857.142857142859
R_L1_m_43_36 pixel_43 l1_msum_36 241379.31034482759
R_L1_m_44_36 pixel_44 l1_msum_36 1000000
R_L1_m_45_36 pixel_45 l1_msum_36 95890.410958904104
R_L1_m_46_36 pixel_46 l1_msum_36 28112.449799196787
R_L1_m_47_36 pixel_47 l1_msum_36 54687.499999999993
R_L1_m_48_36 pixel_48 l1_msum_36 50359.712230215831
R_L1_m_49_36 pixel_49 l1_msum_36 54687.499999999993
R_L1_m_50_36 pixel_50 l1_msum_36 32407.407407407409
R_L1_m_51_36 pixel_51 l1_msum_36 137254.90196078431
R_L1_m_52_36 pixel_52 l1_msum_36 1000000
R_L1_m_53_36 pixel_53 l1_msum_36 1000000
R_L1_m_54_36 pixel_54 l1_msum_36 28112.449799196787
R_L1_m_55_36 pixel_55 l1_msum_36 1000000
R_L1_m_56_36 pixel_56 l1_msum_36 40697.674418604649
R_L1_m_57_36 pixel_57 l1_msum_36 83333.333333333328
R_L1_m_58_36 pixel_58 l1_msum_36 73684.210526315786
R_L1_m_59_36 pixel_59 l1_msum_36 1000000
R_L1_m_60_36 pixel_60 l1_msum_36 1000000
R_L1_m_61_36 pixel_61 l1_msum_36 1000000
R_L1_m_62_36 pixel_62 l1_msum_36 1000000
R_L1_m_63_36 pixel_63 l1_msum_36 46666.666666666664
E_TIA_L1_m_36 l1_mout_36 0 0 l1_msum_36 100000000
R_FB_L1_m_36 l1_mout_36 l1_msum_36 1000
B_NEURON_L1_36 hidden_36 0 V={0.01*max(((V(l1_mout_36)-V(l1_pout_36))/0.0030903275574088963+(0.41503530740737915)),0)}
R_L1_p_0_37 pixel_0 l1_psum_37 83333.333333333328
R_L1_p_1_37 pixel_1 l1_psum_37 175000.00000000003
R_L1_p_2_37 pixel_2 l1_psum_37 175000.00000000003
R_L1_p_3_37 pixel_3 l1_psum_37 23890.784982935158
R_L1_p_4_37 pixel_4 l1_psum_37 24822.695035460994
R_L1_p_5_37 pixel_5 l1_psum_37 18918.91891891892
R_L1_p_6_37 pixel_6 l1_psum_37 175000.00000000003
R_L1_p_7_37 pixel_7 l1_psum_37 241379.31034482759
R_L1_p_8_37 pixel_8 l1_psum_37 59829.059829059821
R_L1_p_9_37 pixel_9 l1_psum_37 1000000
R_L1_p_10_37 pixel_10 l1_psum_37 1000000
R_L1_p_11_37 pixel_11 l1_psum_37 66037.735849056597
R_L1_p_12_37 pixel_12 l1_psum_37 59829.059829059821
R_L1_p_13_37 pixel_13 l1_psum_37 83333.333333333328
R_L1_p_14_37 pixel_14 l1_psum_37 54687.499999999993
R_L1_p_15_37 pixel_15 l1_psum_37 40697.674418604649
R_L1_p_16_37 pixel_16 l1_psum_37 1000000
R_L1_p_17_37 pixel_17 l1_psum_37 1000000
R_L1_p_18_37 pixel_18 l1_psum_37 34146.341463414632
R_L1_p_19_37 pixel_19 l1_psum_37 28112.449799196787
R_L1_p_20_37 pixel_20 l1_psum_37 1000000
R_L1_p_21_37 pixel_21 l1_psum_37 1000000
R_L1_p_22_37 pixel_22 l1_psum_37 1000000
R_L1_p_23_37 pixel_23 l1_psum_37 1000000
R_L1_p_24_37 pixel_24 l1_psum_37 73684.210526315786
R_L1_p_25_37 pixel_25 l1_psum_37 83333.333333333328
R_L1_p_26_37 pixel_26 l1_psum_37 175000.00000000003
R_L1_p_27_37 pixel_27 l1_psum_37 1000000
R_L1_p_28_37 pixel_28 l1_psum_37 388888.88888888888
R_L1_p_29_37 pixel_29 l1_psum_37 241379.31034482759
R_L1_p_30_37 pixel_30 l1_psum_37 1000000
R_L1_p_31_37 pixel_31 l1_psum_37 1000000
R_L1_p_32_37 pixel_32 l1_psum_37 36082.474226804123
R_L1_p_33_37 pixel_33 l1_psum_37 137254.90196078431
R_L1_p_34_37 pixel_34 l1_psum_37 1000000
R_L1_p_35_37 pixel_35 l1_psum_37 1000000
R_L1_p_36_37 pixel_36 l1_psum_37 1000000
R_L1_p_37_37 pixel_37 l1_psum_37 1000000
R_L1_p_38_37 pixel_38 l1_psum_37 43478.260869565216
R_L1_p_39_37 pixel_39 l1_psum_37 1000000
R_L1_p_40_37 pixel_40 l1_psum_37 25830.258302583028
R_L1_p_41_37 pixel_41 l1_psum_37 175000.00000000003
R_L1_p_42_37 pixel_42 l1_psum_37 388888.88888888888
R_L1_p_43_37 pixel_43 l1_psum_37 1000000
R_L1_p_44_37 pixel_44 l1_psum_37 95890.410958904104
R_L1_p_45_37 pixel_45 l1_psum_37 83333.333333333328
R_L1_p_46_37 pixel_46 l1_psum_37 1000000
R_L1_p_47_37 pixel_47 l1_psum_37 1000000
R_L1_p_48_37 pixel_48 l1_psum_37 1000000
R_L1_p_49_37 pixel_49 l1_psum_37 175000.00000000003
R_L1_p_50_37 pixel_50 l1_psum_37 1000000
R_L1_p_51_37 pixel_51 l1_psum_37 54687.499999999993
R_L1_p_52_37 pixel_52 l1_psum_37 38251.366120218576
R_L1_p_53_37 pixel_53 l1_psum_37 83333.333333333328
R_L1_p_54_37 pixel_54 l1_psum_37 1000000
R_L1_p_55_37 pixel_55 l1_psum_37 54687.499999999993
R_L1_p_56_37 pixel_56 l1_psum_37 112903.22580645159
R_L1_p_57_37 pixel_57 l1_psum_37 1000000
R_L1_p_58_37 pixel_58 l1_psum_37 175000.00000000003
R_L1_p_59_37 pixel_59 l1_psum_37 83333.333333333328
R_L1_p_60_37 pixel_60 l1_psum_37 95890.410958904104
R_L1_p_61_37 pixel_61 l1_psum_37 32407.407407407409
R_L1_p_62_37 pixel_62 l1_psum_37 16470.588235294119
R_L1_p_63_37 pixel_63 l1_psum_37 175000.00000000003
E_TIA_L1_p_37 l1_pout_37 0 0 l1_psum_37 100000000
R_FB_L1_p_37 l1_pout_37 l1_psum_37 1000
R_L1_m_0_37 pixel_0 l1_msum_37 1000000
R_L1_m_1_37 pixel_1 l1_msum_37 1000000
R_L1_m_2_37 pixel_2 l1_msum_37 1000000
R_L1_m_3_37 pixel_3 l1_msum_37 1000000
R_L1_m_4_37 pixel_4 l1_msum_37 1000000
R_L1_m_5_37 pixel_5 l1_msum_37 1000000
R_L1_m_6_37 pixel_6 l1_msum_37 1000000
R_L1_m_7_37 pixel_7 l1_msum_37 1000000
R_L1_m_8_37 pixel_8 l1_msum_37 1000000
R_L1_m_9_37 pixel_9 l1_msum_37 388888.88888888888
R_L1_m_10_37 pixel_10 l1_msum_37 175000.00000000003
R_L1_m_11_37 pixel_11 l1_msum_37 1000000
R_L1_m_12_37 pixel_12 l1_msum_37 1000000
R_L1_m_13_37 pixel_13 l1_msum_37 1000000
R_L1_m_14_37 pixel_14 l1_msum_37 1000000
R_L1_m_15_37 pixel_15 l1_msum_37 1000000
R_L1_m_16_37 pixel_16 l1_msum_37 1000000
R_L1_m_17_37 pixel_17 l1_msum_37 241379.31034482759
R_L1_m_18_37 pixel_18 l1_msum_37 1000000
R_L1_m_19_37 pixel_19 l1_msum_37 1000000
R_L1_m_20_37 pixel_20 l1_msum_37 83333.333333333328
R_L1_m_21_37 pixel_21 l1_msum_37 43478.260869565216
R_L1_m_22_37 pixel_22 l1_msum_37 54687.499999999993
R_L1_m_23_37 pixel_23 l1_msum_37 1000000
R_L1_m_24_37 pixel_24 l1_msum_37 1000000
R_L1_m_25_37 pixel_25 l1_msum_37 1000000
R_L1_m_26_37 pixel_26 l1_msum_37 1000000
R_L1_m_27_37 pixel_27 l1_msum_37 32407.407407407409
R_L1_m_28_37 pixel_28 l1_msum_37 1000000
R_L1_m_29_37 pixel_29 l1_msum_37 1000000
R_L1_m_30_37 pixel_30 l1_msum_37 1000000
R_L1_m_31_37 pixel_31 l1_msum_37 38251.366120218576
R_L1_m_32_37 pixel_32 l1_msum_37 1000000
R_L1_m_33_37 pixel_33 l1_msum_37 1000000
R_L1_m_34_37 pixel_34 l1_msum_37 112903.22580645159
R_L1_m_35_37 pixel_35 l1_msum_37 50359.712230215831
R_L1_m_36_37 pixel_36 l1_msum_37 59829.059829059821
R_L1_m_37_37 pixel_37 l1_msum_37 1000000
R_L1_m_38_37 pixel_38 l1_msum_37 1000000
R_L1_m_39_37 pixel_39 l1_msum_37 34146.341463414632
R_L1_m_40_37 pixel_40 l1_msum_37 1000000
R_L1_m_41_37 pixel_41 l1_msum_37 1000000
R_L1_m_42_37 pixel_42 l1_msum_37 1000000
R_L1_m_43_37 pixel_43 l1_msum_37 30837.004405286345
R_L1_m_44_37 pixel_44 l1_msum_37 1000000
R_L1_m_45_37 pixel_45 l1_msum_37 1000000
R_L1_m_46_37 pixel_46 l1_msum_37 1000000
R_L1_m_47_37 pixel_47 l1_msum_37 1000000
R_L1_m_48_37 pixel_48 l1_msum_37 137254.90196078431
R_L1_m_49_37 pixel_49 l1_msum_37 1000000
R_L1_m_50_37 pixel_50 l1_msum_37 83333.333333333328
R_L1_m_51_37 pixel_51 l1_msum_37 1000000
R_L1_m_52_37 pixel_52 l1_msum_37 1000000
R_L1_m_53_37 pixel_53 l1_msum_37 1000000
R_L1_m_54_37 pixel_54 l1_msum_37 137254.90196078431
R_L1_m_55_37 pixel_55 l1_msum_37 1000000
R_L1_m_56_37 pixel_56 l1_msum_37 1000000
R_L1_m_57_37 pixel_57 l1_msum_37 30837.004405286345
R_L1_m_58_37 pixel_58 l1_msum_37 1000000
R_L1_m_59_37 pixel_59 l1_msum_37 1000000
R_L1_m_60_37 pixel_60 l1_msum_37 1000000
R_L1_m_61_37 pixel_61 l1_msum_37 1000000
R_L1_m_62_37 pixel_62 l1_msum_37 1000000
R_L1_m_63_37 pixel_63 l1_msum_37 1000000
E_TIA_L1_m_37 l1_mout_37 0 0 l1_msum_37 100000000
R_FB_L1_m_37 l1_mout_37 l1_msum_37 1000
B_NEURON_L1_37 hidden_37 0 V={0.01*max(((V(l1_mout_37)-V(l1_pout_37))/0.0030903275574088963+(0.025738557800650597)),0)}
R_L1_p_0_38 pixel_0 l1_psum_38 175000.00000000003
R_L1_p_1_38 pixel_1 l1_psum_38 34146.341463414632
R_L1_p_2_38 pixel_2 l1_psum_38 25830.258302583028
R_L1_p_3_38 pixel_3 l1_psum_38 36082.474226804123
R_L1_p_4_38 pixel_4 l1_psum_38 388888.88888888888
R_L1_p_5_38 pixel_5 l1_psum_38 175000.00000000003
R_L1_p_6_38 pixel_6 l1_psum_38 1000000
R_L1_p_7_38 pixel_7 l1_psum_38 26923.076923076922
R_L1_p_8_38 pixel_8 l1_psum_38 50359.712230215831
R_L1_p_9_38 pixel_9 l1_psum_38 43478.260869565216
R_L1_p_10_38 pixel_10 l1_psum_38 29411.764705882353
R_L1_p_11_38 pixel_11 l1_psum_38 66037.735849056597
R_L1_p_12_38 pixel_12 l1_psum_38 1000000
R_L1_p_13_38 pixel_13 l1_psum_38 1000000
R_L1_p_14_38 pixel_14 l1_psum_38 1000000
R_L1_p_15_38 pixel_15 l1_psum_38 50359.712230215831
R_L1_p_16_38 pixel_16 l1_psum_38 38251.366120218576
R_L1_p_17_38 pixel_17 l1_psum_38 1000000
R_L1_p_18_38 pixel_18 l1_psum_38 1000000
R_L1_p_19_38 pixel_19 l1_psum_38 1000000
R_L1_p_20_38 pixel_20 l1_psum_38 1000000
R_L1_p_21_38 pixel_21 l1_psum_38 112903.22580645159
R_L1_p_22_38 pixel_22 l1_psum_38 1000000
R_L1_p_23_38 pixel_23 l1_psum_38 1000000
R_L1_p_24_38 pixel_24 l1_psum_38 36082.474226804123
R_L1_p_25_38 pixel_25 l1_psum_38 1000000
R_L1_p_26_38 pixel_26 l1_psum_38 137254.90196078431
R_L1_p_27_38 pixel_27 l1_psum_38 54687.499999999993
R_L1_p_28_38 pixel_28 l1_psum_38 83333.333333333328
R_L1_p_29_38 pixel_29 l1_psum_38 83333.333333333328
R_L1_p_30_38 pixel_30 l1_psum_38 1000000
R_L1_p_31_38 pixel_31 l1_psum_38 1000000
R_L1_p_32_38 pixel_32 l1_psum_38 25830.258302583028
R_L1_p_33_38 pixel_33 l1_psum_38 1000000
R_L1_p_34_38 pixel_34 l1_psum_38 1000000
R_L1_p_35_38 pixel_35 l1_psum_38 1000000
R_L1_p_36_38 pixel_36 l1_psum_38 40697.674418604649
R_L1_p_37_38 pixel_37 l1_psum_38 30837.004405286345
R_L1_p_38_38 pixel_38 l1_psum_38 137254.90196078431
R_L1_p_39_38 pixel_39 l1_psum_38 175000.00000000003
R_L1_p_40_38 pixel_40 l1_psum_38 30837.004405286345
R_L1_p_41_38 pixel_41 l1_psum_38 83333.333333333328
R_L1_p_42_38 pixel_42 l1_psum_38 1000000
R_L1_p_43_38 pixel_43 l1_psum_38 175000.00000000003
R_L1_p_44_38 pixel_44 l1_psum_38 73684.210526315786
R_L1_p_45_38 pixel_45 l1_psum_38 1000000
R_L1_p_46_38 pixel_46 l1_psum_38 1000000
R_L1_p_47_38 pixel_47 l1_psum_38 1000000
R_L1_p_48_38 pixel_48 l1_psum_38 175000.00000000003
R_L1_p_49_38 pixel_49 l1_psum_38 1000000
R_L1_p_50_38 pixel_50 l1_psum_38 46666.666666666664
R_L1_p_51_38 pixel_51 l1_psum_38 175000.00000000003
R_L1_p_52_38 pixel_52 l1_psum_38 1000000
R_L1_p_53_38 pixel_53 l1_psum_38 1000000
R_L1_p_54_38 pixel_54 l1_psum_38 1000000
R_L1_p_55_38 pixel_55 l1_psum_38 1000000
R_L1_p_56_38 pixel_56 l1_psum_38 66037.735849056597
R_L1_p_57_38 pixel_57 l1_psum_38 43478.260869565216
R_L1_p_58_38 pixel_58 l1_psum_38 59829.059829059821
R_L1_p_59_38 pixel_59 l1_psum_38 46666.666666666664
R_L1_p_60_38 pixel_60 l1_psum_38 241379.31034482759
R_L1_p_61_38 pixel_61 l1_psum_38 1000000
R_L1_p_62_38 pixel_62 l1_psum_38 388888.88888888888
R_L1_p_63_38 pixel_63 l1_psum_38 1000000
E_TIA_L1_p_38 l1_pout_38 0 0 l1_psum_38 100000000
R_FB_L1_p_38 l1_pout_38 l1_psum_38 1000
R_L1_m_0_38 pixel_0 l1_msum_38 1000000
R_L1_m_1_38 pixel_1 l1_msum_38 1000000
R_L1_m_2_38 pixel_2 l1_msum_38 1000000
R_L1_m_3_38 pixel_3 l1_msum_38 1000000
R_L1_m_4_38 pixel_4 l1_msum_38 1000000
R_L1_m_5_38 pixel_5 l1_msum_38 1000000
R_L1_m_6_38 pixel_6 l1_msum_38 112903.22580645159
R_L1_m_7_38 pixel_7 l1_msum_38 1000000
R_L1_m_8_38 pixel_8 l1_msum_38 1000000
R_L1_m_9_38 pixel_9 l1_msum_38 1000000
R_L1_m_10_38 pixel_10 l1_msum_38 1000000
R_L1_m_11_38 pixel_11 l1_msum_38 1000000
R_L1_m_12_38 pixel_12 l1_msum_38 73684.210526315786
R_L1_m_13_38 pixel_13 l1_msum_38 36082.474226804123
R_L1_m_14_38 pixel_14 l1_msum_38 83333.333333333328
R_L1_m_15_38 pixel_15 l1_msum_38 1000000
R_L1_m_16_38 pixel_16 l1_msum_38 1000000
R_L1_m_17_38 pixel_17 l1_msum_38 1000000
R_L1_m_18_38 pixel_18 l1_msum_38 175000.00000000003
R_L1_m_19_38 pixel_19 l1_msum_38 66037.735849056597
R_L1_m_20_38 pixel_20 l1_msum_38 175000.00000000003
R_L1_m_21_38 pixel_21 l1_msum_38 1000000
R_L1_m_22_38 pixel_22 l1_msum_38 66037.735849056597
R_L1_m_23_38 pixel_23 l1_msum_38 46666.666666666664
R_L1_m_24_38 pixel_24 l1_msum_38 1000000
R_L1_m_25_38 pixel_25 l1_msum_38 137254.90196078431
R_L1_m_26_38 pixel_26 l1_msum_38 1000000
R_L1_m_27_38 pixel_27 l1_msum_38 1000000
R_L1_m_28_38 pixel_28 l1_msum_38 1000000
R_L1_m_29_38 pixel_29 l1_msum_38 1000000
R_L1_m_30_38 pixel_30 l1_msum_38 73684.210526315786
R_L1_m_31_38 pixel_31 l1_msum_38 43478.260869565216
R_L1_m_32_38 pixel_32 l1_msum_38 1000000
R_L1_m_33_38 pixel_33 l1_msum_38 137254.90196078431
R_L1_m_34_38 pixel_34 l1_msum_38 388888.88888888888
R_L1_m_35_38 pixel_35 l1_msum_38 66037.735849056597
R_L1_m_36_38 pixel_36 l1_msum_38 1000000
R_L1_m_37_38 pixel_37 l1_msum_38 1000000
R_L1_m_38_38 pixel_38 l1_msum_38 1000000
R_L1_m_39_38 pixel_39 l1_msum_38 1000000
R_L1_m_40_38 pixel_40 l1_msum_38 1000000
R_L1_m_41_38 pixel_41 l1_msum_38 1000000
R_L1_m_42_38 pixel_42 l1_msum_38 73684.210526315786
R_L1_m_43_38 pixel_43 l1_msum_38 1000000
R_L1_m_44_38 pixel_44 l1_msum_38 1000000
R_L1_m_45_38 pixel_45 l1_msum_38 54687.499999999993
R_L1_m_46_38 pixel_46 l1_msum_38 29411.764705882353
R_L1_m_47_38 pixel_47 l1_msum_38 112903.22580645159
R_L1_m_48_38 pixel_48 l1_msum_38 1000000
R_L1_m_49_38 pixel_49 l1_msum_38 112903.22580645159
R_L1_m_50_38 pixel_50 l1_msum_38 1000000
R_L1_m_51_38 pixel_51 l1_msum_38 1000000
R_L1_m_52_38 pixel_52 l1_msum_38 30837.004405286345
R_L1_m_53_38 pixel_53 l1_msum_38 20114.942528735632
R_L1_m_54_38 pixel_54 l1_msum_38 20771.51335311573
R_L1_m_55_38 pixel_55 l1_msum_38 112903.22580645159
R_L1_m_56_38 pixel_56 l1_msum_38 1000000
R_L1_m_57_38 pixel_57 l1_msum_38 1000000
R_L1_m_58_38 pixel_58 l1_msum_38 1000000
R_L1_m_59_38 pixel_59 l1_msum_38 1000000
R_L1_m_60_38 pixel_60 l1_msum_38 1000000
R_L1_m_61_38 pixel_61 l1_msum_38 36082.474226804123
R_L1_m_62_38 pixel_62 l1_msum_38 1000000
R_L1_m_63_38 pixel_63 l1_msum_38 73684.210526315786
E_TIA_L1_m_38 l1_mout_38 0 0 l1_msum_38 100000000
R_FB_L1_m_38 l1_mout_38 l1_msum_38 1000
B_NEURON_L1_38 hidden_38 0 V={0.01*max(((V(l1_mout_38)-V(l1_pout_38))/0.0030903275574088963+(-0.11505331099033356)),0)}
R_L1_p_0_39 pixel_0 l1_psum_39 241379.31034482759
R_L1_p_1_39 pixel_1 l1_psum_39 137254.90196078431
R_L1_p_2_39 pixel_2 l1_psum_39 112903.22580645159
R_L1_p_3_39 pixel_3 l1_psum_39 1000000
R_L1_p_4_39 pixel_4 l1_psum_39 43478.260869565216
R_L1_p_5_39 pixel_5 l1_psum_39 34146.341463414632
R_L1_p_6_39 pixel_6 l1_psum_39 16055.045871559634
R_L1_p_7_39 pixel_7 l1_psum_39 175000.00000000003
R_L1_p_8_39 pixel_8 l1_psum_39 1000000
R_L1_p_9_39 pixel_9 l1_psum_39 1000000
R_L1_p_10_39 pixel_10 l1_psum_39 1000000
R_L1_p_11_39 pixel_11 l1_psum_39 95890.410958904104
R_L1_p_12_39 pixel_12 l1_psum_39 1000000
R_L1_p_13_39 pixel_13 l1_psum_39 1000000
R_L1_p_14_39 pixel_14 l1_psum_39 112903.22580645159
R_L1_p_15_39 pixel_15 l1_psum_39 23890.784982935158
R_L1_p_16_39 pixel_16 l1_psum_39 1000000
R_L1_p_17_39 pixel_17 l1_psum_39 1000000
R_L1_p_18_39 pixel_18 l1_psum_39 66037.735849056597
R_L1_p_19_39 pixel_19 l1_psum_39 59829.059829059821
R_L1_p_20_39 pixel_20 l1_psum_39 1000000
R_L1_p_21_39 pixel_21 l1_psum_39 1000000
R_L1_p_22_39 pixel_22 l1_psum_39 1000000
R_L1_p_23_39 pixel_23 l1_psum_39 25830.258302583028
R_L1_p_24_39 pixel_24 l1_psum_39 1000000
R_L1_p_25_39 pixel_25 l1_psum_39 1000000
R_L1_p_26_39 pixel_26 l1_psum_39 1000000
R_L1_p_27_39 pixel_27 l1_psum_39 95890.410958904104
R_L1_p_28_39 pixel_28 l1_psum_39 241379.31034482759
R_L1_p_29_39 pixel_29 l1_psum_39 137254.90196078431
R_L1_p_30_39 pixel_30 l1_psum_39 38251.366120218576
R_L1_p_31_39 pixel_31 l1_psum_39 21472.39263803681
R_L1_p_32_39 pixel_32 l1_psum_39 1000000
R_L1_p_33_39 pixel_33 l1_psum_39 1000000
R_L1_p_34_39 pixel_34 l1_psum_39 1000000
R_L1_p_35_39 pixel_35 l1_psum_39 18918.91891891892
R_L1_p_36_39 pixel_36 l1_psum_39 1000000
R_L1_p_37_39 pixel_37 l1_psum_39 175000.00000000003
R_L1_p_38_39 pixel_38 l1_psum_39 175000.00000000003
R_L1_p_39_39 pixel_39 l1_psum_39 28112.449799196787
R_L1_p_40_39 pixel_40 l1_psum_39 1000000
R_L1_p_41_39 pixel_41 l1_psum_39 1000000
R_L1_p_42_39 pixel_42 l1_psum_39 32407.407407407409
R_L1_p_43_39 pixel_43 l1_psum_39 175000.00000000003
R_L1_p_44_39 pixel_44 l1_psum_39 1000000
R_L1_p_45_39 pixel_45 l1_psum_39 1000000
R_L1_p_46_39 pixel_46 l1_psum_39 1000000
R_L1_p_47_39 pixel_47 l1_psum_39 137254.90196078431
R_L1_p_48_39 pixel_48 l1_psum_39 1000000
R_L1_p_49_39 pixel_49 l1_psum_39 1000000
R_L1_p_50_39 pixel_50 l1_psum_39 1000000
R_L1_p_51_39 pixel_51 l1_psum_39 83333.333333333328
R_L1_p_52_39 pixel_52 l1_psum_39 1000000
R_L1_p_53_39 pixel_53 l1_psum_39 1000000
R_L1_p_54_39 pixel_54 l1_psum_39 1000000
R_L1_p_55_39 pixel_55 l1_psum_39 1000000
R_L1_p_56_39 pixel_56 l1_psum_39 95890.410958904104
R_L1_p_57_39 pixel_57 l1_psum_39 1000000
R_L1_p_58_39 pixel_58 l1_psum_39 1000000
R_L1_p_59_39 pixel_59 l1_psum_39 1000000
R_L1_p_60_39 pixel_60 l1_psum_39 1000000
R_L1_p_61_39 pixel_61 l1_psum_39 1000000
R_L1_p_62_39 pixel_62 l1_psum_39 1000000
R_L1_p_63_39 pixel_63 l1_psum_39 388888.88888888888
E_TIA_L1_p_39 l1_pout_39 0 0 l1_psum_39 100000000
R_FB_L1_p_39 l1_pout_39 l1_psum_39 1000
R_L1_m_0_39 pixel_0 l1_msum_39 1000000
R_L1_m_1_39 pixel_1 l1_msum_39 1000000
R_L1_m_2_39 pixel_2 l1_msum_39 1000000
R_L1_m_3_39 pixel_3 l1_msum_39 1000000
R_L1_m_4_39 pixel_4 l1_msum_39 1000000
R_L1_m_5_39 pixel_5 l1_msum_39 1000000
R_L1_m_6_39 pixel_6 l1_msum_39 1000000
R_L1_m_7_39 pixel_7 l1_msum_39 1000000
R_L1_m_8_39 pixel_8 l1_msum_39 28112.449799196787
R_L1_m_9_39 pixel_9 l1_msum_39 36082.474226804123
R_L1_m_10_39 pixel_10 l1_msum_39 83333.333333333328
R_L1_m_11_39 pixel_11 l1_msum_39 1000000
R_L1_m_12_39 pixel_12 l1_msum_39 175000.00000000003
R_L1_m_13_39 pixel_13 l1_msum_39 175000.00000000003
R_L1_m_14_39 pixel_14 l1_msum_39 1000000
R_L1_m_15_39 pixel_15 l1_msum_39 1000000
R_L1_m_16_39 pixel_16 l1_msum_39 17369.727047146403
R_L1_m_17_39 pixel_17 l1_msum_39 21472.39263803681
R_L1_m_18_39 pixel_18 l1_msum_39 1000000
R_L1_m_19_39 pixel_19 l1_msum_39 1000000
R_L1_m_20_39 pixel_20 l1_msum_39 26923.076923076922
R_L1_m_21_39 pixel_21 l1_msum_39 46666.666666666664
R_L1_m_22_39 pixel_22 l1_msum_39 83333.333333333328
R_L1_m_23_39 pixel_23 l1_msum_39 1000000
R_L1_m_24_39 pixel_24 l1_msum_39 28112.449799196787
R_L1_m_25_39 pixel_25 l1_msum_39 73684.210526315786
R_L1_m_26_39 pixel_26 l1_msum_39 59829.059829059821
R_L1_m_27_39 pixel_27 l1_msum_39 1000000
R_L1_m_28_39 pixel_28 l1_msum_39 1000000
R_L1_m_29_39 pixel_29 l1_msum_39 1000000
R_L1_m_30_39 pixel_30 l1_msum_39 1000000
R_L1_m_31_39 pixel_31 l1_msum_39 1000000
R_L1_m_32_39 pixel_32 l1_msum_39 40697.674418604649
R_L1_m_33_39 pixel_33 l1_msum_39 43478.260869565216
R_L1_m_34_39 pixel_34 l1_msum_39 241379.31034482759
R_L1_m_35_39 pixel_35 l1_msum_39 1000000
R_L1_m_36_39 pixel_36 l1_msum_39 137254.90196078431
R_L1_m_37_39 pixel_37 l1_msum_39 1000000
R_L1_m_38_39 pixel_38 l1_msum_39 1000000
R_L1_m_39_39 pixel_39 l1_msum_39 1000000
R_L1_m_40_39 pixel_40 l1_msum_39 83333.333333333328
R_L1_m_41_39 pixel_41 l1_msum_39 46666.666666666664
R_L1_m_42_39 pixel_42 l1_msum_39 1000000
R_L1_m_43_39 pixel_43 l1_msum_39 1000000
R_L1_m_44_39 pixel_44 l1_msum_39 54687.499999999993
R_L1_m_45_39 pixel_45 l1_msum_39 73684.210526315786
R_L1_m_46_39 pixel_46 l1_msum_39 83333.333333333328
R_L1_m_47_39 pixel_47 l1_msum_39 1000000
R_L1_m_48_39 pixel_48 l1_msum_39 388888.88888888888
R_L1_m_49_39 pixel_49 l1_msum_39 175000.00000000003
R_L1_m_50_39 pixel_50 l1_msum_39 1000000
R_L1_m_51_39 pixel_51 l1_msum_39 1000000
R_L1_m_52_39 pixel_52 l1_msum_39 241379.31034482759
R_L1_m_53_39 pixel_53 l1_msum_39 83333.333333333328
R_L1_m_54_39 pixel_54 l1_msum_39 50359.712230215831
R_L1_m_55_39 pixel_55 l1_msum_39 83333.333333333328
R_L1_m_56_39 pixel_56 l1_msum_39 1000000
R_L1_m_57_39 pixel_57 l1_msum_39 66037.735849056597
R_L1_m_58_39 pixel_58 l1_msum_39 23890.784982935158
R_L1_m_59_39 pixel_59 l1_msum_39 137254.90196078431
R_L1_m_60_39 pixel_60 l1_msum_39 73684.210526315786
R_L1_m_61_39 pixel_61 l1_msum_39 16055.045871559634
R_L1_m_62_39 pixel_62 l1_msum_39 22222.222222222223
R_L1_m_63_39 pixel_63 l1_msum_39 1000000
E_TIA_L1_m_39 l1_mout_39 0 0 l1_msum_39 100000000
R_FB_L1_m_39 l1_mout_39 l1_msum_39 1000
B_NEURON_L1_39 hidden_39 0 V={0.01*max(((V(l1_mout_39)-V(l1_pout_39))/0.0030903275574088963+(0.30269938707351685)),0)}
R_L1_p_0_40 pixel_0 l1_psum_40 1000000
R_L1_p_1_40 pixel_1 l1_psum_40 1000000
R_L1_p_2_40 pixel_2 l1_psum_40 1000000
R_L1_p_3_40 pixel_3 l1_psum_40 1000000
R_L1_p_4_40 pixel_4 l1_psum_40 1000000
R_L1_p_5_40 pixel_5 l1_psum_40 1000000
R_L1_p_6_40 pixel_6 l1_psum_40 1000000
R_L1_p_7_40 pixel_7 l1_psum_40 1000000
R_L1_p_8_40 pixel_8 l1_psum_40 30837.004405286345
R_L1_p_9_40 pixel_9 l1_psum_40 73684.210526315786
R_L1_p_10_40 pixel_10 l1_psum_40 388888.88888888888
R_L1_p_11_40 pixel_11 l1_psum_40 73684.210526315786
R_L1_p_12_40 pixel_12 l1_psum_40 1000000
R_L1_p_13_40 pixel_13 l1_psum_40 1000000
R_L1_p_14_40 pixel_14 l1_psum_40 1000000
R_L1_p_15_40 pixel_15 l1_psum_40 1000000
R_L1_p_16_40 pixel_16 l1_psum_40 1000000
R_L1_p_17_40 pixel_17 l1_psum_40 1000000
R_L1_p_18_40 pixel_18 l1_psum_40 241379.31034482759
R_L1_p_19_40 pixel_19 l1_psum_40 1000000
R_L1_p_20_40 pixel_20 l1_psum_40 1000000
R_L1_p_21_40 pixel_21 l1_psum_40 1000000
R_L1_p_22_40 pixel_22 l1_psum_40 1000000
R_L1_p_23_40 pixel_23 l1_psum_40 1000000
R_L1_p_24_40 pixel_24 l1_psum_40 1000000
R_L1_p_25_40 pixel_25 l1_psum_40 1000000
R_L1_p_26_40 pixel_26 l1_psum_40 137254.90196078431
R_L1_p_27_40 pixel_27 l1_psum_40 73684.210526315786
R_L1_p_28_40 pixel_28 l1_psum_40 38251.366120218576
R_L1_p_29_40 pixel_29 l1_psum_40 95890.410958904104
R_L1_p_30_40 pixel_30 l1_psum_40 1000000
R_L1_p_31_40 pixel_31 l1_psum_40 1000000
R_L1_p_32_40 pixel_32 l1_psum_40 1000000
R_L1_p_33_40 pixel_33 l1_psum_40 1000000
R_L1_p_34_40 pixel_34 l1_psum_40 95890.410958904104
R_L1_p_35_40 pixel_35 l1_psum_40 34146.341463414632
R_L1_p_36_40 pixel_36 l1_psum_40 54687.499999999993
R_L1_p_37_40 pixel_37 l1_psum_40 388888.88888888888
R_L1_p_38_40 pixel_38 l1_psum_40 1000000
R_L1_p_39_40 pixel_39 l1_psum_40 1000000
R_L1_p_40_40 pixel_40 l1_psum_40 24822.695035460994
R_L1_p_41_40 pixel_41 l1_psum_40 1000000
R_L1_p_42_40 pixel_42 l1_psum_40 1000000
R_L1_p_43_40 pixel_43 l1_psum_40 1000000
R_L1_p_44_40 pixel_44 l1_psum_40 1000000
R_L1_p_45_40 pixel_45 l1_psum_40 1000000
R_L1_p_46_40 pixel_46 l1_psum_40 1000000
R_L1_p_47_40 pixel_47 l1_psum_40 1000000
R_L1_p_48_40 pixel_48 l1_psum_40 16055.045871559634
R_L1_p_49_40 pixel_49 l1_psum_40 28112.449799196787
R_L1_p_50_40 pixel_50 l1_psum_40 46666.666666666664
R_L1_p_51_40 pixel_51 l1_psum_40 1000000
R_L1_p_52_40 pixel_52 l1_psum_40 1000000
R_L1_p_53_40 pixel_53 l1_psum_40 1000000
R_L1_p_54_40 pixel_54 l1_psum_40 1000000
R_L1_p_55_40 pixel_55 l1_psum_40 30837.004405286345
R_L1_p_56_40 pixel_56 l1_psum_40 1000000
R_L1_p_57_40 pixel_57 l1_psum_40 95890.410958904104
R_L1_p_58_40 pixel_58 l1_psum_40 83333.333333333328
R_L1_p_59_40 pixel_59 l1_psum_40 175000.00000000003
R_L1_p_60_40 pixel_60 l1_psum_40 73684.210526315786
R_L1_p_61_40 pixel_61 l1_psum_40 73684.210526315786
R_L1_p_62_40 pixel_62 l1_psum_40 1000000
R_L1_p_63_40 pixel_63 l1_psum_40 1000000
E_TIA_L1_p_40 l1_pout_40 0 0 l1_psum_40 100000000
R_FB_L1_p_40 l1_pout_40 l1_psum_40 1000
R_L1_m_0_40 pixel_0 l1_msum_40 175000.00000000003
R_L1_m_1_40 pixel_1 l1_msum_40 95890.410958904104
R_L1_m_2_40 pixel_2 l1_msum_40 28112.449799196787
R_L1_m_3_40 pixel_3 l1_msum_40 40697.674418604649
R_L1_m_4_40 pixel_4 l1_msum_40 13358.778625954199
R_L1_m_5_40 pixel_5 l1_msum_40 23890.784982935158
R_L1_m_6_40 pixel_6 l1_msum_40 23026.315789473687
R_L1_m_7_40 pixel_7 l1_msum_40 388888.88888888888
R_L1_m_8_40 pixel_8 l1_msum_40 1000000
R_L1_m_9_40 pixel_9 l1_msum_40 1000000
R_L1_m_10_40 pixel_10 l1_msum_40 1000000
R_L1_m_11_40 pixel_11 l1_msum_40 1000000
R_L1_m_12_40 pixel_12 l1_msum_40 241379.31034482759
R_L1_m_13_40 pixel_13 l1_msum_40 112903.22580645159
R_L1_m_14_40 pixel_14 l1_msum_40 388888.88888888888
R_L1_m_15_40 pixel_15 l1_msum_40 43478.260869565216
R_L1_m_16_40 pixel_16 l1_msum_40 26923.076923076922
R_L1_m_17_40 pixel_17 l1_msum_40 29411.764705882353
R_L1_m_18_40 pixel_18 l1_msum_40 1000000
R_L1_m_19_40 pixel_19 l1_msum_40 95890.410958904104
R_L1_m_20_40 pixel_20 l1_msum_40 241379.31034482759
R_L1_m_21_40 pixel_21 l1_msum_40 73684.210526315786
R_L1_m_22_40 pixel_22 l1_msum_40 73684.210526315786
R_L1_m_23_40 pixel_23 l1_msum_40 175000.00000000003
R_L1_m_24_40 pixel_24 l1_msum_40 30837.004405286345
R_L1_m_25_40 pixel_25 l1_msum_40 40697.674418604649
R_L1_m_26_40 pixel_26 l1_msum_40 1000000
R_L1_m_27_40 pixel_27 l1_msum_40 1000000
R_L1_m_28_40 pixel_28 l1_msum_40 1000000
R_L1_m_29_40 pixel_29 l1_msum_40 1000000
R_L1_m_30_40 pixel_30 l1_msum_40 241379.31034482759
R_L1_m_31_40 pixel_31 l1_msum_40 83333.333333333328
R_L1_m_32_40 pixel_32 l1_msum_40 66037.735849056597
R_L1_m_33_40 pixel_33 l1_msum_40 21472.39263803681
R_L1_m_34_40 pixel_34 l1_msum_40 1000000
R_L1_m_35_40 pixel_35 l1_msum_40 1000000
R_L1_m_36_40 pixel_36 l1_msum_40 1000000
R_L1_m_37_40 pixel_37 l1_msum_40 1000000
R_L1_m_38_40 pixel_38 l1_msum_40 15659.955257270693
R_L1_m_39_40 pixel_39 l1_msum_40 24822.695035460994
R_L1_m_40_40 pixel_40 l1_msum_40 1000000
R_L1_m_41_40 pixel_41 l1_msum_40 23026.315789473687
R_L1_m_42_40 pixel_42 l1_msum_40 14583.333333333334
R_L1_m_43_40 pixel_43 l1_msum_40 54687.499999999993
R_L1_m_44_40 pixel_44 l1_msum_40 73684.210526315786
R_L1_m_45_40 pixel_45 l1_msum_40 32407.407407407409
R_L1_m_46_40 pixel_46 l1_msum_40 24822.695035460994
R_L1_m_47_40 pixel_47 l1_msum_40 175000.00000000003
R_L1_m_48_40 pixel_48 l1_msum_40 1000000
R_L1_m_49_40 pixel_49 l1_msum_40 1000000
R_L1_m_50_40 pixel_50 l1_msum_40 1000000
R_L1_m_51_40 pixel_51 l1_msum_40 66037.735849056597
R_L1_m_52_40 pixel_52 l1_msum_40 50359.712230215831
R_L1_m_53_40 pixel_53 l1_msum_40 54687.499999999993
R_L1_m_54_40 pixel_54 l1_msum_40 46666.666666666664
R_L1_m_55_40 pixel_55 l1_msum_40 1000000
R_L1_m_56_40 pixel_56 l1_msum_40 175000.00000000003
R_L1_m_57_40 pixel_57 l1_msum_40 1000000
R_L1_m_58_40 pixel_58 l1_msum_40 1000000
R_L1_m_59_40 pixel_59 l1_msum_40 1000000
R_L1_m_60_40 pixel_60 l1_msum_40 1000000
R_L1_m_61_40 pixel_61 l1_msum_40 1000000
R_L1_m_62_40 pixel_62 l1_msum_40 388888.88888888888
R_L1_m_63_40 pixel_63 l1_msum_40 1000000
E_TIA_L1_m_40 l1_mout_40 0 0 l1_msum_40 100000000
R_FB_L1_m_40 l1_mout_40 l1_msum_40 1000
B_NEURON_L1_40 hidden_40 0 V={0.01*max(((V(l1_mout_40)-V(l1_pout_40))/0.0030903275574088963+(0.24701131880283356)),0)}
R_L1_p_0_41 pixel_0 l1_psum_41 43478.260869565216
R_L1_p_1_41 pixel_1 l1_psum_41 1000000
R_L1_p_2_41 pixel_2 l1_psum_41 112903.22580645159
R_L1_p_3_41 pixel_3 l1_psum_41 175000.00000000003
R_L1_p_4_41 pixel_4 l1_psum_41 112903.22580645159
R_L1_p_5_41 pixel_5 l1_psum_41 59829.059829059821
R_L1_p_6_41 pixel_6 l1_psum_41 95890.410958904104
R_L1_p_7_41 pixel_7 l1_psum_41 1000000
R_L1_p_8_41 pixel_8 l1_psum_41 95890.410958904104
R_L1_p_9_41 pixel_9 l1_psum_41 1000000
R_L1_p_10_41 pixel_10 l1_psum_41 1000000
R_L1_p_11_41 pixel_11 l1_psum_41 1000000
R_L1_p_12_41 pixel_12 l1_psum_41 1000000
R_L1_p_13_41 pixel_13 l1_psum_41 1000000
R_L1_p_14_41 pixel_14 l1_psum_41 388888.88888888888
R_L1_p_15_41 pixel_15 l1_psum_41 1000000
R_L1_p_16_41 pixel_16 l1_psum_41 59829.059829059821
R_L1_p_17_41 pixel_17 l1_psum_41 1000000
R_L1_p_18_41 pixel_18 l1_psum_41 1000000
R_L1_p_19_41 pixel_19 l1_psum_41 388888.88888888888
R_L1_p_20_41 pixel_20 l1_psum_41 54687.499999999993
R_L1_p_21_41 pixel_21 l1_psum_41 83333.333333333328
R_L1_p_22_41 pixel_22 l1_psum_41 50359.712230215831
R_L1_p_23_41 pixel_23 l1_psum_41 23890.784982935158
R_L1_p_24_41 pixel_24 l1_psum_41 30837.004405286345
R_L1_p_25_41 pixel_25 l1_psum_41 1000000
R_L1_p_26_41 pixel_26 l1_psum_41 1000000
R_L1_p_27_41 pixel_27 l1_psum_41 59829.059829059821
R_L1_p_28_41 pixel_28 l1_psum_41 34146.341463414632
R_L1_p_29_41 pixel_29 l1_psum_41 112903.22580645159
R_L1_p_30_41 pixel_30 l1_psum_41 1000000
R_L1_p_31_41 pixel_31 l1_psum_41 43478.260869565216
R_L1_p_32_41 pixel_32 l1_psum_41 137254.90196078431
R_L1_p_33_41 pixel_33 l1_psum_41 95890.410958904104
R_L1_p_34_41 pixel_34 l1_psum_41 1000000
R_L1_p_35_41 pixel_35 l1_psum_41 1000000
R_L1_p_36_41 pixel_36 l1_psum_41 1000000
R_L1_p_37_41 pixel_37 l1_psum_41 59829.059829059821
R_L1_p_38_41 pixel_38 l1_psum_41 1000000
R_L1_p_39_41 pixel_39 l1_psum_41 1000000
R_L1_p_40_41 pixel_40 l1_psum_41 1000000
R_L1_p_41_41 pixel_41 l1_psum_41 73684.210526315786
R_L1_p_42_41 pixel_42 l1_psum_41 83333.333333333328
R_L1_p_43_41 pixel_43 l1_psum_41 388888.88888888888
R_L1_p_44_41 pixel_44 l1_psum_41 50359.712230215831
R_L1_p_45_41 pixel_45 l1_psum_41 1000000
R_L1_p_46_41 pixel_46 l1_psum_41 1000000
R_L1_p_47_41 pixel_47 l1_psum_41 388888.88888888888
R_L1_p_48_41 pixel_48 l1_psum_41 1000000
R_L1_p_49_41 pixel_49 l1_psum_41 1000000
R_L1_p_50_41 pixel_50 l1_psum_41 1000000
R_L1_p_51_41 pixel_51 l1_psum_41 1000000
R_L1_p_52_41 pixel_52 l1_psum_41 1000000
R_L1_p_53_41 pixel_53 l1_psum_41 1000000
R_L1_p_54_41 pixel_54 l1_psum_41 1000000
R_L1_p_55_41 pixel_55 l1_psum_41 1000000
R_L1_p_56_41 pixel_56 l1_psum_41 46666.666666666664
R_L1_p_57_41 pixel_57 l1_psum_41 29411.764705882353
R_L1_p_58_41 pixel_58 l1_psum_41 17369.727047146403
R_L1_p_59_41 pixel_59 l1_psum_41 25830.258302583028
R_L1_p_60_41 pixel_60 l1_psum_41 112903.22580645159
R_L1_p_61_41 pixel_61 l1_psum_41 388888.88888888888
R_L1_p_62_41 pixel_62 l1_psum_41 66037.735849056597
R_L1_p_63_41 pixel_63 l1_psum_41 1000000
E_TIA_L1_p_41 l1_pout_41 0 0 l1_psum_41 100000000
R_FB_L1_p_41 l1_pout_41 l1_psum_41 1000
R_L1_m_0_41 pixel_0 l1_msum_41 1000000
R_L1_m_1_41 pixel_1 l1_msum_41 83333.333333333328
R_L1_m_2_41 pixel_2 l1_msum_41 1000000
R_L1_m_3_41 pixel_3 l1_msum_41 1000000
R_L1_m_4_41 pixel_4 l1_msum_41 1000000
R_L1_m_5_41 pixel_5 l1_msum_41 1000000
R_L1_m_6_41 pixel_6 l1_msum_41 1000000
R_L1_m_7_41 pixel_7 l1_msum_41 83333.333333333328
R_L1_m_8_41 pixel_8 l1_msum_41 1000000
R_L1_m_9_41 pixel_9 l1_msum_41 73684.210526315786
R_L1_m_10_41 pixel_10 l1_msum_41 66037.735849056597
R_L1_m_11_41 pixel_11 l1_msum_41 388888.88888888888
R_L1_m_12_41 pixel_12 l1_msum_41 95890.410958904104
R_L1_m_13_41 pixel_13 l1_msum_41 1000000
R_L1_m_14_41 pixel_14 l1_msum_41 1000000
R_L1_m_15_41 pixel_15 l1_msum_41 95890.410958904104
R_L1_m_16_41 pixel_16 l1_msum_41 1000000
R_L1_m_17_41 pixel_17 l1_msum_41 43478.260869565216
R_L1_m_18_41 pixel_18 l1_msum_41 46666.666666666664
R_L1_m_19_41 pixel_19 l1_msum_41 1000000
R_L1_m_20_41 pixel_20 l1_msum_41 1000000
R_L1_m_21_41 pixel_21 l1_msum_41 1000000
R_L1_m_22_41 pixel_22 l1_msum_41 1000000
R_L1_m_23_41 pixel_23 l1_msum_41 1000000
R_L1_m_24_41 pixel_24 l1_msum_41 1000000
R_L1_m_25_41 pixel_25 l1_msum_41 175000.00000000003
R_L1_m_26_41 pixel_26 l1_msum_41 32407.407407407409
R_L1_m_27_41 pixel_27 l1_msum_41 1000000
R_L1_m_28_41 pixel_28 l1_msum_41 1000000
R_L1_m_29_41 pixel_29 l1_msum_41 1000000
R_L1_m_30_41 pixel_30 l1_msum_41 388888.88888888888
R_L1_m_31_41 pixel_31 l1_msum_41 1000000
R_L1_m_32_41 pixel_32 l1_msum_41 1000000
R_L1_m_33_41 pixel_33 l1_msum_41 1000000
R_L1_m_34_41 pixel_34 l1_msum_41 23890.784982935158
R_L1_m_35_41 pixel_35 l1_msum_41 50359.712230215831
R_L1_m_36_41 pixel_36 l1_msum_41 175000.00000000003
R_L1_m_37_41 pixel_37 l1_msum_41 1000000
R_L1_m_38_41 pixel_38 l1_msum_41 32407.407407407409
R_L1_m_39_41 pixel_39 l1_msum_41 24822.695035460994
R_L1_m_40_41 pixel_40 l1_msum_41 175000.00000000003
R_L1_m_41_41 pixel_41 l1_msum_41 1000000
R_L1_m_42_41 pixel_42 l1_msum_41 1000000
R_L1_m_43_41 pixel_43 l1_msum_41 1000000
R_L1_m_44_41 pixel_44 l1_msum_41 1000000
R_L1_m_45_41 pixel_45 l1_msum_41 388888.88888888888
R_L1_m_46_41 pixel_46 l1_msum_41 36082.474226804123
R_L1_m_47_41 pixel_47 l1_msum_41 1000000
R_L1_m_48_41 pixel_48 l1_msum_41 40697.674418604649
R_L1_m_49_41 pixel_49 l1_msum_41 137254.90196078431
R_L1_m_50_41 pixel_50 l1_msum_41 112903.22580645159
R_L1_m_51_41 pixel_51 l1_msum_41 137254.90196078431
R_L1_m_52_41 pixel_52 l1_msum_41 241379.31034482759
R_L1_m_53_41 pixel_53 l1_msum_41 28112.449799196787
R_L1_m_54_41 pixel_54 l1_msum_41 24822.695035460994
R_L1_m_55_41 pixel_55 l1_msum_41 40697.674418604649
R_L1_m_56_41 pixel_56 l1_msum_41 1000000
R_L1_m_57_41 pixel_57 l1_msum_41 1000000
R_L1_m_58_41 pixel_58 l1_msum_41 1000000
R_L1_m_59_41 pixel_59 l1_msum_41 1000000
R_L1_m_60_41 pixel_60 l1_msum_41 1000000
R_L1_m_61_41 pixel_61 l1_msum_41 1000000
R_L1_m_62_41 pixel_62 l1_msum_41 1000000
R_L1_m_63_41 pixel_63 l1_msum_41 1000000
E_TIA_L1_m_41 l1_mout_41 0 0 l1_msum_41 100000000
R_FB_L1_m_41 l1_mout_41 l1_msum_41 1000
B_NEURON_L1_41 hidden_41 0 V={0.01*max(((V(l1_mout_41)-V(l1_pout_41))/0.0030903275574088963+(0.23360095918178558)),0)}
R_L1_p_0_42 pixel_0 l1_psum_42 388888.88888888888
R_L1_p_1_42 pixel_1 l1_psum_42 1000000
R_L1_p_2_42 pixel_2 l1_psum_42 1000000
R_L1_p_3_42 pixel_3 l1_psum_42 241379.31034482759
R_L1_p_4_42 pixel_4 l1_psum_42 241379.31034482759
R_L1_p_5_42 pixel_5 l1_psum_42 83333.333333333328
R_L1_p_6_42 pixel_6 l1_psum_42 1000000
R_L1_p_7_42 pixel_7 l1_psum_42 1000000
R_L1_p_8_42 pixel_8 l1_psum_42 46666.666666666664
R_L1_p_9_42 pixel_9 l1_psum_42 1000000
R_L1_p_10_42 pixel_10 l1_psum_42 1000000
R_L1_p_11_42 pixel_11 l1_psum_42 1000000
R_L1_p_12_42 pixel_12 l1_psum_42 1000000
R_L1_p_13_42 pixel_13 l1_psum_42 1000000
R_L1_p_14_42 pixel_14 l1_psum_42 1000000
R_L1_p_15_42 pixel_15 l1_psum_42 1000000
R_L1_p_16_42 pixel_16 l1_psum_42 59829.059829059821
R_L1_p_17_42 pixel_17 l1_psum_42 175000.00000000003
R_L1_p_18_42 pixel_18 l1_psum_42 112903.22580645159
R_L1_p_19_42 pixel_19 l1_psum_42 1000000
R_L1_p_20_42 pixel_20 l1_psum_42 43478.260869565216
R_L1_p_21_42 pixel_21 l1_psum_42 50359.712230215831
R_L1_p_22_42 pixel_22 l1_psum_42 29411.764705882353
R_L1_p_23_42 pixel_23 l1_psum_42 59829.059829059821
R_L1_p_24_42 pixel_24 l1_psum_42 388888.88888888888
R_L1_p_25_42 pixel_25 l1_psum_42 73684.210526315786
R_L1_p_26_42 pixel_26 l1_psum_42 59829.059829059821
R_L1_p_27_42 pixel_27 l1_psum_42 1000000
R_L1_p_28_42 pixel_28 l1_psum_42 1000000
R_L1_p_29_42 pixel_29 l1_psum_42 1000000
R_L1_p_30_42 pixel_30 l1_psum_42 1000000
R_L1_p_31_42 pixel_31 l1_psum_42 73684.210526315786
R_L1_p_32_42 pixel_32 l1_psum_42 1000000
R_L1_p_33_42 pixel_33 l1_psum_42 388888.88888888888
R_L1_p_34_42 pixel_34 l1_psum_42 32407.407407407409
R_L1_p_35_42 pixel_35 l1_psum_42 26923.076923076922
R_L1_p_36_42 pixel_36 l1_psum_42 59829.059829059821
R_L1_p_37_42 pixel_37 l1_psum_42 241379.31034482759
R_L1_p_38_42 pixel_38 l1_psum_42 1000000
R_L1_p_39_42 pixel_39 l1_psum_42 1000000
R_L1_p_40_42 pixel_40 l1_psum_42 1000000
R_L1_p_41_42 pixel_41 l1_psum_42 1000000
R_L1_p_42_42 pixel_42 l1_psum_42 1000000
R_L1_p_43_42 pixel_43 l1_psum_42 1000000
R_L1_p_44_42 pixel_44 l1_psum_42 95890.410958904104
R_L1_p_45_42 pixel_45 l1_psum_42 241379.31034482759
R_L1_p_46_42 pixel_46 l1_psum_42 1000000
R_L1_p_47_42 pixel_47 l1_psum_42 1000000
R_L1_p_48_42 pixel_48 l1_psum_42 1000000
R_L1_p_49_42 pixel_49 l1_psum_42 54687.499999999993
R_L1_p_50_42 pixel_50 l1_psum_42 73684.210526315786
R_L1_p_51_42 pixel_51 l1_psum_42 1000000
R_L1_p_52_42 pixel_52 l1_psum_42 175000.00000000003
R_L1_p_53_42 pixel_53 l1_psum_42 95890.410958904104
R_L1_p_54_42 pixel_54 l1_psum_42 112903.22580645159
R_L1_p_55_42 pixel_55 l1_psum_42 1000000
R_L1_p_56_42 pixel_56 l1_psum_42 46666.666666666664
R_L1_p_57_42 pixel_57 l1_psum_42 95890.410958904104
R_L1_p_58_42 pixel_58 l1_psum_42 1000000
R_L1_p_59_42 pixel_59 l1_psum_42 40697.674418604649
R_L1_p_60_42 pixel_60 l1_psum_42 23890.784982935158
R_L1_p_61_42 pixel_61 l1_psum_42 34146.341463414632
R_L1_p_62_42 pixel_62 l1_psum_42 46666.666666666664
R_L1_p_63_42 pixel_63 l1_psum_42 1000000
E_TIA_L1_p_42 l1_pout_42 0 0 l1_psum_42 100000000
R_FB_L1_p_42 l1_pout_42 l1_psum_42 1000
R_L1_m_0_42 pixel_0 l1_msum_42 1000000
R_L1_m_1_42 pixel_1 l1_msum_42 34146.341463414632
R_L1_m_2_42 pixel_2 l1_msum_42 73684.210526315786
R_L1_m_3_42 pixel_3 l1_msum_42 1000000
R_L1_m_4_42 pixel_4 l1_msum_42 1000000
R_L1_m_5_42 pixel_5 l1_msum_42 1000000
R_L1_m_6_42 pixel_6 l1_msum_42 30837.004405286345
R_L1_m_7_42 pixel_7 l1_msum_42 43478.260869565216
R_L1_m_8_42 pixel_8 l1_msum_42 1000000
R_L1_m_9_42 pixel_9 l1_msum_42 73684.210526315786
R_L1_m_10_42 pixel_10 l1_msum_42 95890.410958904104
R_L1_m_11_42 pixel_11 l1_msum_42 241379.31034482759
R_L1_m_12_42 pixel_12 l1_msum_42 59829.059829059821
R_L1_m_13_42 pixel_13 l1_msum_42 59829.059829059821
R_L1_m_14_42 pixel_14 l1_msum_42 73684.210526315786
R_L1_m_15_42 pixel_15 l1_msum_42 30837.004405286345
R_L1_m_16_42 pixel_16 l1_msum_42 1000000
R_L1_m_17_42 pixel_17 l1_msum_42 1000000
R_L1_m_18_42 pixel_18 l1_msum_42 1000000
R_L1_m_19_42 pixel_19 l1_msum_42 112903.22580645159
R_L1_m_20_42 pixel_20 l1_msum_42 1000000
R_L1_m_21_42 pixel_21 l1_msum_42 1000000
R_L1_m_22_42 pixel_22 l1_msum_42 1000000
R_L1_m_23_42 pixel_23 l1_msum_42 1000000
R_L1_m_24_42 pixel_24 l1_msum_42 1000000
R_L1_m_25_42 pixel_25 l1_msum_42 1000000
R_L1_m_26_42 pixel_26 l1_msum_42 1000000
R_L1_m_27_42 pixel_27 l1_msum_42 40697.674418604649
R_L1_m_28_42 pixel_28 l1_msum_42 23026.315789473687
R_L1_m_29_42 pixel_29 l1_msum_42 30837.004405286345
R_L1_m_30_42 pixel_30 l1_msum_42 66037.735849056597
R_L1_m_31_42 pixel_31 l1_msum_42 1000000
R_L1_m_32_42 pixel_32 l1_msum_42 36082.474226804123
R_L1_m_33_42 pixel_33 l1_msum_42 1000000
R_L1_m_34_42 pixel_34 l1_msum_42 1000000
R_L1_m_35_42 pixel_35 l1_msum_42 1000000
R_L1_m_36_42 pixel_36 l1_msum_42 1000000
R_L1_m_37_42 pixel_37 l1_msum_42 1000000
R_L1_m_38_42 pixel_38 l1_msum_42 24822.695035460994
R_L1_m_39_42 pixel_39 l1_msum_42 20114.942528735632
R_L1_m_40_42 pixel_40 l1_msum_42 19498.607242339833
R_L1_m_41_42 pixel_41 l1_msum_42 25830.258302583028
R_L1_m_42_42 pixel_42 l1_msum_42 36082.474226804123
R_L1_m_43_42 pixel_43 l1_msum_42 241379.31034482759
R_L1_m_44_42 pixel_44 l1_msum_42 1000000
R_L1_m_45_42 pixel_45 l1_msum_42 1000000
R_L1_m_46_42 pixel_46 l1_msum_42 95890.410958904104
R_L1_m_47_42 pixel_47 l1_msum_42 36082.474226804123
R_L1_m_48_42 pixel_48 l1_msum_42 241379.31034482759
R_L1_m_49_42 pixel_49 l1_msum_42 1000000
R_L1_m_50_42 pixel_50 l1_msum_42 1000000
R_L1_m_51_42 pixel_51 l1_msum_42 388888.88888888888
R_L1_m_52_42 pixel_52 l1_msum_42 1000000
R_L1_m_53_42 pixel_53 l1_msum_42 1000000
R_L1_m_54_42 pixel_54 l1_msum_42 1000000
R_L1_m_55_42 pixel_55 l1_msum_42 30837.004405286345
R_L1_m_56_42 pixel_56 l1_msum_42 1000000
R_L1_m_57_42 pixel_57 l1_msum_42 1000000
R_L1_m_58_42 pixel_58 l1_msum_42 137254.90196078431
R_L1_m_59_42 pixel_59 l1_msum_42 1000000
R_L1_m_60_42 pixel_60 l1_msum_42 1000000
R_L1_m_61_42 pixel_61 l1_msum_42 1000000
R_L1_m_62_42 pixel_62 l1_msum_42 1000000
R_L1_m_63_42 pixel_63 l1_msum_42 83333.333333333328
E_TIA_L1_m_42 l1_mout_42 0 0 l1_msum_42 100000000
R_FB_L1_m_42 l1_mout_42 l1_msum_42 1000
B_NEURON_L1_42 hidden_42 0 V={0.01*max(((V(l1_mout_42)-V(l1_pout_42))/0.0030903275574088963+(0.089878864586353302)),0)}
R_L1_p_0_43 pixel_0 l1_psum_43 1000000
R_L1_p_1_43 pixel_1 l1_psum_43 175000.00000000003
R_L1_p_2_43 pixel_2 l1_psum_43 95890.410958904104
R_L1_p_3_43 pixel_3 l1_psum_43 28112.449799196787
R_L1_p_4_43 pixel_4 l1_psum_43 20771.51335311573
R_L1_p_5_43 pixel_5 l1_psum_43 112903.22580645159
R_L1_p_6_43 pixel_6 l1_psum_43 1000000
R_L1_p_7_43 pixel_7 l1_psum_43 95890.410958904104
R_L1_p_8_43 pixel_8 l1_psum_43 40697.674418604649
R_L1_p_9_43 pixel_9 l1_psum_43 83333.333333333328
R_L1_p_10_43 pixel_10 l1_psum_43 1000000
R_L1_p_11_43 pixel_11 l1_psum_43 1000000
R_L1_p_12_43 pixel_12 l1_psum_43 46666.666666666664
R_L1_p_13_43 pixel_13 l1_psum_43 112903.22580645159
R_L1_p_14_43 pixel_14 l1_psum_43 1000000
R_L1_p_15_43 pixel_15 l1_psum_43 1000000
R_L1_p_16_43 pixel_16 l1_psum_43 25830.258302583028
R_L1_p_17_43 pixel_17 l1_psum_43 241379.31034482759
R_L1_p_18_43 pixel_18 l1_psum_43 1000000
R_L1_p_19_43 pixel_19 l1_psum_43 1000000
R_L1_p_20_43 pixel_20 l1_psum_43 38251.366120218576
R_L1_p_21_43 pixel_21 l1_psum_43 388888.88888888888
R_L1_p_22_43 pixel_22 l1_psum_43 1000000
R_L1_p_23_43 pixel_23 l1_psum_43 1000000
R_L1_p_24_43 pixel_24 l1_psum_43 83333.333333333328
R_L1_p_25_43 pixel_25 l1_psum_43 1000000
R_L1_p_26_43 pixel_26 l1_psum_43 1000000
R_L1_p_27_43 pixel_27 l1_psum_43 1000000
R_L1_p_28_43 pixel_28 l1_psum_43 137254.90196078431
R_L1_p_29_43 pixel_29 l1_psum_43 1000000
R_L1_p_30_43 pixel_30 l1_psum_43 1000000
R_L1_p_31_43 pixel_31 l1_psum_43 54687.499999999993
R_L1_p_32_43 pixel_32 l1_psum_43 34146.341463414632
R_L1_p_33_43 pixel_33 l1_psum_43 83333.333333333328
R_L1_p_34_43 pixel_34 l1_psum_43 137254.90196078431
R_L1_p_35_43 pixel_35 l1_psum_43 1000000
R_L1_p_36_43 pixel_36 l1_psum_43 83333.333333333328
R_L1_p_37_43 pixel_37 l1_psum_43 73684.210526315786
R_L1_p_38_43 pixel_38 l1_psum_43 40697.674418604649
R_L1_p_39_43 pixel_39 l1_psum_43 32407.407407407409
R_L1_p_40_43 pixel_40 l1_psum_43 40697.674418604649
R_L1_p_41_43 pixel_41 l1_psum_43 59829.059829059821
R_L1_p_42_43 pixel_42 l1_psum_43 83333.333333333328
R_L1_p_43_43 pixel_43 l1_psum_43 1000000
R_L1_p_44_43 pixel_44 l1_psum_43 43478.260869565216
R_L1_p_45_43 pixel_45 l1_psum_43 50359.712230215831
R_L1_p_46_43 pixel_46 l1_psum_43 95890.410958904104
R_L1_p_47_43 pixel_47 l1_psum_43 241379.31034482759
R_L1_p_48_43 pixel_48 l1_psum_43 24822.695035460994
R_L1_p_49_43 pixel_49 l1_psum_43 1000000
R_L1_p_50_43 pixel_50 l1_psum_43 137254.90196078431
R_L1_p_51_43 pixel_51 l1_psum_43 1000000
R_L1_p_52_43 pixel_52 l1_psum_43 175000.00000000003
R_L1_p_53_43 pixel_53 l1_psum_43 1000000
R_L1_p_54_43 pixel_54 l1_psum_43 1000000
R_L1_p_55_43 pixel_55 l1_psum_43 112903.22580645159
R_L1_p_56_43 pixel_56 l1_psum_43 241379.31034482759
R_L1_p_57_43 pixel_57 l1_psum_43 241379.31034482759
R_L1_p_58_43 pixel_58 l1_psum_43 46666.666666666664
R_L1_p_59_43 pixel_59 l1_psum_43 1000000
R_L1_p_60_43 pixel_60 l1_psum_43 1000000
R_L1_p_61_43 pixel_61 l1_psum_43 1000000
R_L1_p_62_43 pixel_62 l1_psum_43 1000000
R_L1_p_63_43 pixel_63 l1_psum_43 388888.88888888888
E_TIA_L1_p_43 l1_pout_43 0 0 l1_psum_43 100000000
R_FB_L1_p_43 l1_pout_43 l1_psum_43 1000
R_L1_m_0_43 pixel_0 l1_msum_43 137254.90196078431
R_L1_m_1_43 pixel_1 l1_msum_43 1000000
R_L1_m_2_43 pixel_2 l1_msum_43 1000000
R_L1_m_3_43 pixel_3 l1_msum_43 1000000
R_L1_m_4_43 pixel_4 l1_msum_43 1000000
R_L1_m_5_43 pixel_5 l1_msum_43 1000000
R_L1_m_6_43 pixel_6 l1_msum_43 34146.341463414632
R_L1_m_7_43 pixel_7 l1_msum_43 1000000
R_L1_m_8_43 pixel_8 l1_msum_43 1000000
R_L1_m_9_43 pixel_9 l1_msum_43 1000000
R_L1_m_10_43 pixel_10 l1_msum_43 388888.88888888888
R_L1_m_11_43 pixel_11 l1_msum_43 83333.333333333328
R_L1_m_12_43 pixel_12 l1_msum_43 1000000
R_L1_m_13_43 pixel_13 l1_msum_43 1000000
R_L1_m_14_43 pixel_14 l1_msum_43 21472.39263803681
R_L1_m_15_43 pixel_15 l1_msum_43 30837.004405286345
R_L1_m_16_43 pixel_16 l1_msum_43 1000000
R_L1_m_17_43 pixel_17 l1_msum_43 1000000
R_L1_m_18_43 pixel_18 l1_msum_43 54687.499999999993
R_L1_m_19_43 pixel_19 l1_msum_43 20114.942528735632
R_L1_m_20_43 pixel_20 l1_msum_43 1000000
R_L1_m_21_43 pixel_21 l1_msum_43 1000000
R_L1_m_22_43 pixel_22 l1_msum_43 15659.955257270693
R_L1_m_23_43 pixel_23 l1_msum_43 20771.51335311573
R_L1_m_24_43 pixel_24 l1_msum_43 1000000
R_L1_m_25_43 pixel_25 l1_msum_43 54687.499999999993
R_L1_m_26_43 pixel_26 l1_msum_43 95890.410958904104
R_L1_m_27_43 pixel_27 l1_msum_43 112903.22580645159
R_L1_m_28_43 pixel_28 l1_msum_43 1000000
R_L1_m_29_43 pixel_29 l1_msum_43 50359.712230215831
R_L1_m_30_43 pixel_30 l1_msum_43 32407.407407407409
R_L1_m_31_43 pixel_31 l1_msum_43 1000000
R_L1_m_32_43 pixel_32 l1_msum_43 1000000
R_L1_m_33_43 pixel_33 l1_msum_43 1000000
R_L1_m_34_43 pixel_34 l1_msum_43 1000000
R_L1_m_35_43 pixel_35 l1_msum_43 1000000
R_L1_m_36_43 pixel_36 l1_msum_43 1000000
R_L1_m_37_43 pixel_37 l1_msum_43 1000000
R_L1_m_38_43 pixel_38 l1_msum_43 1000000
R_L1_m_39_43 pixel_39 l1_msum_43 1000000
R_L1_m_40_43 pixel_40 l1_msum_43 1000000
R_L1_m_41_43 pixel_41 l1_msum_43 1000000
R_L1_m_42_43 pixel_42 l1_msum_43 1000000
R_L1_m_43_43 pixel_43 l1_msum_43 66037.735849056597
R_L1_m_44_43 pixel_44 l1_msum_43 1000000
R_L1_m_45_43 pixel_45 l1_msum_43 1000000
R_L1_m_46_43 pixel_46 l1_msum_43 1000000
R_L1_m_47_43 pixel_47 l1_msum_43 1000000
R_L1_m_48_43 pixel_48 l1_msum_43 1000000
R_L1_m_49_43 pixel_49 l1_msum_43 83333.333333333328
R_L1_m_50_43 pixel_50 l1_msum_43 1000000
R_L1_m_51_43 pixel_51 l1_msum_43 137254.90196078431
R_L1_m_52_43 pixel_52 l1_msum_43 1000000
R_L1_m_53_43 pixel_53 l1_msum_43 137254.90196078431
R_L1_m_54_43 pixel_54 l1_msum_43 95890.410958904104
R_L1_m_55_43 pixel_55 l1_msum_43 1000000
R_L1_m_56_43 pixel_56 l1_msum_43 1000000
R_L1_m_57_43 pixel_57 l1_msum_43 1000000
R_L1_m_58_43 pixel_58 l1_msum_43 1000000
R_L1_m_59_43 pixel_59 l1_msum_43 95890.410958904104
R_L1_m_60_43 pixel_60 l1_msum_43 26923.076923076922
R_L1_m_61_43 pixel_61 l1_msum_43 112903.22580645159
R_L1_m_62_43 pixel_62 l1_msum_43 46666.666666666664
R_L1_m_63_43 pixel_63 l1_msum_43 1000000
E_TIA_L1_m_43 l1_mout_43 0 0 l1_msum_43 100000000
R_FB_L1_m_43 l1_mout_43 l1_msum_43 1000
B_NEURON_L1_43 hidden_43 0 V={0.01*max(((V(l1_mout_43)-V(l1_pout_43))/0.0030903275574088963+(0.062433186918497086)),0)}
R_L1_p_0_44 pixel_0 l1_psum_44 1000000
R_L1_p_1_44 pixel_1 l1_psum_44 83333.333333333328
R_L1_p_2_44 pixel_2 l1_psum_44 95890.410958904104
R_L1_p_3_44 pixel_3 l1_psum_44 388888.88888888888
R_L1_p_4_44 pixel_4 l1_psum_44 1000000
R_L1_p_5_44 pixel_5 l1_psum_44 112903.22580645159
R_L1_p_6_44 pixel_6 l1_psum_44 66037.735849056597
R_L1_p_7_44 pixel_7 l1_psum_44 32407.407407407409
R_L1_p_8_44 pixel_8 l1_psum_44 1000000
R_L1_p_9_44 pixel_9 l1_psum_44 1000000
R_L1_p_10_44 pixel_10 l1_psum_44 1000000
R_L1_p_11_44 pixel_11 l1_psum_44 83333.333333333328
R_L1_p_12_44 pixel_12 l1_psum_44 1000000
R_L1_p_13_44 pixel_13 l1_psum_44 1000000
R_L1_p_14_44 pixel_14 l1_psum_44 1000000
R_L1_p_15_44 pixel_15 l1_psum_44 137254.90196078431
R_L1_p_16_44 pixel_16 l1_psum_44 1000000
R_L1_p_17_44 pixel_17 l1_psum_44 1000000
R_L1_p_18_44 pixel_18 l1_psum_44 1000000
R_L1_p_19_44 pixel_19 l1_psum_44 95890.410958904104
R_L1_p_20_44 pixel_20 l1_psum_44 1000000
R_L1_p_21_44 pixel_21 l1_psum_44 1000000
R_L1_p_22_44 pixel_22 l1_psum_44 175000.00000000003
R_L1_p_23_44 pixel_23 l1_psum_44 59829.059829059821
R_L1_p_24_44 pixel_24 l1_psum_44 1000000
R_L1_p_25_44 pixel_25 l1_psum_44 1000000
R_L1_p_26_44 pixel_26 l1_psum_44 1000000
R_L1_p_27_44 pixel_27 l1_psum_44 59829.059829059821
R_L1_p_28_44 pixel_28 l1_psum_44 1000000
R_L1_p_29_44 pixel_29 l1_psum_44 1000000
R_L1_p_30_44 pixel_30 l1_psum_44 1000000
R_L1_p_31_44 pixel_31 l1_psum_44 137254.90196078431
R_L1_p_32_44 pixel_32 l1_psum_44 241379.31034482759
R_L1_p_33_44 pixel_33 l1_psum_44 83333.333333333328
R_L1_p_34_44 pixel_34 l1_psum_44 137254.90196078431
R_L1_p_35_44 pixel_35 l1_psum_44 137254.90196078431
R_L1_p_36_44 pixel_36 l1_psum_44 73684.210526315786
R_L1_p_37_44 pixel_37 l1_psum_44 83333.333333333328
R_L1_p_38_44 pixel_38 l1_psum_44 46666.666666666664
R_L1_p_39_44 pixel_39 l1_psum_44 16055.045871559634
R_L1_p_40_44 pixel_40 l1_psum_44 95890.410958904104
R_L1_p_41_44 pixel_41 l1_psum_44 66037.735849056597
R_L1_p_42_44 pixel_42 l1_psum_44 66037.735849056597
R_L1_p_43_44 pixel_43 l1_psum_44 95890.410958904104
R_L1_p_44_44 pixel_44 l1_psum_44 30837.004405286345
R_L1_p_45_44 pixel_45 l1_psum_44 40697.674418604649
R_L1_p_46_44 pixel_46 l1_psum_44 50359.712230215831
R_L1_p_47_44 pixel_47 l1_psum_44 73684.210526315786
R_L1_p_48_44 pixel_48 l1_psum_44 34146.341463414632
R_L1_p_49_44 pixel_49 l1_psum_44 388888.88888888888
R_L1_p_50_44 pixel_50 l1_psum_44 241379.31034482759
R_L1_p_51_44 pixel_51 l1_psum_44 1000000
R_L1_p_52_44 pixel_52 l1_psum_44 1000000
R_L1_p_53_44 pixel_53 l1_psum_44 1000000
R_L1_p_54_44 pixel_54 l1_psum_44 95890.410958904104
R_L1_p_55_44 pixel_55 l1_psum_44 1000000
R_L1_p_56_44 pixel_56 l1_psum_44 1000000
R_L1_p_57_44 pixel_57 l1_psum_44 1000000
R_L1_p_58_44 pixel_58 l1_psum_44 1000000
R_L1_p_59_44 pixel_59 l1_psum_44 1000000
R_L1_p_60_44 pixel_60 l1_psum_44 1000000
R_L1_p_61_44 pixel_61 l1_psum_44 1000000
R_L1_p_62_44 pixel_62 l1_psum_44 1000000
R_L1_p_63_44 pixel_63 l1_psum_44 66037.735849056597
E_TIA_L1_p_44 l1_pout_44 0 0 l1_psum_44 100000000
R_FB_L1_p_44 l1_pout_44 l1_psum_44 1000
R_L1_m_0_44 pixel_0 l1_msum_44 66037.735849056597
R_L1_m_1_44 pixel_1 l1_msum_44 1000000
R_L1_m_2_44 pixel_2 l1_msum_44 1000000
R_L1_m_3_44 pixel_3 l1_msum_44 1000000
R_L1_m_4_44 pixel_4 l1_msum_44 1000000
R_L1_m_5_44 pixel_5 l1_msum_44 1000000
R_L1_m_6_44 pixel_6 l1_msum_44 1000000
R_L1_m_7_44 pixel_7 l1_msum_44 1000000
R_L1_m_8_44 pixel_8 l1_msum_44 50359.712230215831
R_L1_m_9_44 pixel_9 l1_msum_44 388888.88888888888
R_L1_m_10_44 pixel_10 l1_msum_44 36082.474226804123
R_L1_m_11_44 pixel_11 l1_msum_44 1000000
R_L1_m_12_44 pixel_12 l1_msum_44 112903.22580645159
R_L1_m_13_44 pixel_13 l1_msum_44 66037.735849056597
R_L1_m_14_44 pixel_14 l1_msum_44 1000000
R_L1_m_15_44 pixel_15 l1_msum_44 1000000
R_L1_m_16_44 pixel_16 l1_msum_44 32407.407407407409
R_L1_m_17_44 pixel_17 l1_msum_44 46666.666666666664
R_L1_m_18_44 pixel_18 l1_msum_44 24822.695035460994
R_L1_m_19_44 pixel_19 l1_msum_44 1000000
R_L1_m_20_44 pixel_20 l1_msum_44 59829.059829059821
R_L1_m_21_44 pixel_21 l1_msum_44 95890.410958904104
R_L1_m_22_44 pixel_22 l1_msum_44 1000000
R_L1_m_23_44 pixel_23 l1_msum_44 1000000
R_L1_m_24_44 pixel_24 l1_msum_44 28112.449799196787
R_L1_m_25_44 pixel_25 l1_msum_44 40697.674418604649
R_L1_m_26_44 pixel_26 l1_msum_44 137254.90196078431
R_L1_m_27_44 pixel_27 l1_msum_44 1000000
R_L1_m_28_44 pixel_28 l1_msum_44 54687.499999999993
R_L1_m_29_44 pixel_29 l1_msum_44 137254.90196078431
R_L1_m_30_44 pixel_30 l1_msum_44 59829.059829059821
R_L1_m_31_44 pixel_31 l1_msum_44 1000000
R_L1_m_32_44 pixel_32 l1_msum_44 1000000
R_L1_m_33_44 pixel_33 l1_msum_44 1000000
R_L1_m_34_44 pixel_34 l1_msum_44 1000000
R_L1_m_35_44 pixel_35 l1_msum_44 1000000
R_L1_m_36_44 pixel_36 l1_msum_44 1000000
R_L1_m_37_44 pixel_37 l1_msum_44 1000000
R_L1_m_38_44 pixel_38 l1_msum_44 1000000
R_L1_m_39_44 pixel_39 l1_msum_44 1000000
R_L1_m_40_44 pixel_40 l1_msum_44 1000000
R_L1_m_41_44 pixel_41 l1_msum_44 1000000
R_L1_m_42_44 pixel_42 l1_msum_44 1000000
R_L1_m_43_44 pixel_43 l1_msum_44 1000000
R_L1_m_44_44 pixel_44 l1_msum_44 1000000
R_L1_m_45_44 pixel_45 l1_msum_44 1000000
R_L1_m_46_44 pixel_46 l1_msum_44 1000000
R_L1_m_47_44 pixel_47 l1_msum_44 1000000
R_L1_m_48_44 pixel_48 l1_msum_44 1000000
R_L1_m_49_44 pixel_49 l1_msum_44 1000000
R_L1_m_50_44 pixel_50 l1_msum_44 1000000
R_L1_m_51_44 pixel_51 l1_msum_44 83333.333333333328
R_L1_m_52_44 pixel_52 l1_msum_44 34146.341463414632
R_L1_m_53_44 pixel_53 l1_msum_44 95890.410958904104
R_L1_m_54_44 pixel_54 l1_msum_44 1000000
R_L1_m_55_44 pixel_55 l1_msum_44 95890.410958904104
R_L1_m_56_44 pixel_56 l1_msum_44 46666.666666666664
R_L1_m_57_44 pixel_57 l1_msum_44 18918.91891891892
R_L1_m_58_44 pixel_58 l1_msum_44 20771.51335311573
R_L1_m_59_44 pixel_59 l1_msum_44 17857.142857142859
R_L1_m_60_44 pixel_60 l1_msum_44 14256.619144602852
R_L1_m_61_44 pixel_61 l1_msum_44 16908.212560386473
R_L1_m_62_44 pixel_62 l1_msum_44 28112.449799196787
R_L1_m_63_44 pixel_63 l1_msum_44 1000000
E_TIA_L1_m_44 l1_mout_44 0 0 l1_msum_44 100000000
R_FB_L1_m_44 l1_mout_44 l1_msum_44 1000
B_NEURON_L1_44 hidden_44 0 V={0.01*max(((V(l1_mout_44)-V(l1_pout_44))/0.0030903275574088963+(0.20846976339817047)),0)}
R_L1_p_0_45 pixel_0 l1_psum_45 46666.666666666664
R_L1_p_1_45 pixel_1 l1_psum_45 1000000
R_L1_p_2_45 pixel_2 l1_psum_45 1000000
R_L1_p_3_45 pixel_3 l1_psum_45 1000000
R_L1_p_4_45 pixel_4 l1_psum_45 1000000
R_L1_p_5_45 pixel_5 l1_psum_45 1000000
R_L1_p_6_45 pixel_6 l1_psum_45 1000000
R_L1_p_7_45 pixel_7 l1_psum_45 1000000
R_L1_p_8_45 pixel_8 l1_psum_45 34146.341463414632
R_L1_p_9_45 pixel_9 l1_psum_45 73684.210526315786
R_L1_p_10_45 pixel_10 l1_psum_45 95890.410958904104
R_L1_p_11_45 pixel_11 l1_psum_45 112903.22580645159
R_L1_p_12_45 pixel_12 l1_psum_45 241379.31034482759
R_L1_p_13_45 pixel_13 l1_psum_45 83333.333333333328
R_L1_p_14_45 pixel_14 l1_psum_45 1000000
R_L1_p_15_45 pixel_15 l1_psum_45 1000000
R_L1_p_16_45 pixel_16 l1_psum_45 40697.674418604649
R_L1_p_17_45 pixel_17 l1_psum_45 73684.210526315786
R_L1_p_18_45 pixel_18 l1_psum_45 1000000
R_L1_p_19_45 pixel_19 l1_psum_45 1000000
R_L1_p_20_45 pixel_20 l1_psum_45 46666.666666666664
R_L1_p_21_45 pixel_21 l1_psum_45 38251.366120218576
R_L1_p_22_45 pixel_22 l1_psum_45 40697.674418604649
R_L1_p_23_45 pixel_23 l1_psum_45 1000000
R_L1_p_24_45 pixel_24 l1_psum_45 83333.333333333328
R_L1_p_25_45 pixel_25 l1_psum_45 54687.499999999993
R_L1_p_26_45 pixel_26 l1_psum_45 66037.735849056597
R_L1_p_27_45 pixel_27 l1_psum_45 59829.059829059821
R_L1_p_28_45 pixel_28 l1_psum_45 1000000
R_L1_p_29_45 pixel_29 l1_psum_45 137254.90196078431
R_L1_p_30_45 pixel_30 l1_psum_45 1000000
R_L1_p_31_45 pixel_31 l1_psum_45 1000000
R_L1_p_32_45 pixel_32 l1_psum_45 1000000
R_L1_p_33_45 pixel_33 l1_psum_45 59829.059829059821
R_L1_p_34_45 pixel_34 l1_psum_45 241379.31034482759
R_L1_p_35_45 pixel_35 l1_psum_45 1000000
R_L1_p_36_45 pixel_36 l1_psum_45 1000000
R_L1_p_37_45 pixel_37 l1_psum_45 38251.366120218576
R_L1_p_38_45 pixel_38 l1_psum_45 40697.674418604649
R_L1_p_39_45 pixel_39 l1_psum_45 1000000
R_L1_p_40_45 pixel_40 l1_psum_45 112903.22580645159
R_L1_p_41_45 pixel_41 l1_psum_45 1000000
R_L1_p_42_45 pixel_42 l1_psum_45 388888.88888888888
R_L1_p_43_45 pixel_43 l1_psum_45 137254.90196078431
R_L1_p_44_45 pixel_44 l1_psum_45 59829.059829059821
R_L1_p_45_45 pixel_45 l1_psum_45 1000000
R_L1_p_46_45 pixel_46 l1_psum_45 1000000
R_L1_p_47_45 pixel_47 l1_psum_45 1000000
R_L1_p_48_45 pixel_48 l1_psum_45 1000000
R_L1_p_49_45 pixel_49 l1_psum_45 175000.00000000003
R_L1_p_50_45 pixel_50 l1_psum_45 1000000
R_L1_p_51_45 pixel_51 l1_psum_45 83333.333333333328
R_L1_p_52_45 pixel_52 l1_psum_45 175000.00000000003
R_L1_p_53_45 pixel_53 l1_psum_45 1000000
R_L1_p_54_45 pixel_54 l1_psum_45 1000000
R_L1_p_55_45 pixel_55 l1_psum_45 1000000
R_L1_p_56_45 pixel_56 l1_psum_45 50359.712230215831
R_L1_p_57_45 pixel_57 l1_psum_45 23890.784982935158
R_L1_p_58_45 pixel_58 l1_psum_45 83333.333333333328
R_L1_p_59_45 pixel_59 l1_psum_45 175000.00000000003
R_L1_p_60_45 pixel_60 l1_psum_45 1000000
R_L1_p_61_45 pixel_61 l1_psum_45 1000000
R_L1_p_62_45 pixel_62 l1_psum_45 54687.499999999993
R_L1_p_63_45 pixel_63 l1_psum_45 1000000
E_TIA_L1_p_45 l1_pout_45 0 0 l1_psum_45 100000000
R_FB_L1_p_45 l1_pout_45 l1_psum_45 1000
R_L1_m_0_45 pixel_0 l1_msum_45 1000000
R_L1_m_1_45 pixel_1 l1_msum_45 175000.00000000003
R_L1_m_2_45 pixel_2 l1_msum_45 241379.31034482759
R_L1_m_3_45 pixel_3 l1_msum_45 137254.90196078431
R_L1_m_4_45 pixel_4 l1_msum_45 43478.260869565216
R_L1_m_5_45 pixel_5 l1_msum_45 1000000
R_L1_m_6_45 pixel_6 l1_msum_45 40697.674418604649
R_L1_m_7_45 pixel_7 l1_msum_45 137254.90196078431
R_L1_m_8_45 pixel_8 l1_msum_45 1000000
R_L1_m_9_45 pixel_9 l1_msum_45 1000000
R_L1_m_10_45 pixel_10 l1_msum_45 1000000
R_L1_m_11_45 pixel_11 l1_msum_45 1000000
R_L1_m_12_45 pixel_12 l1_msum_45 1000000
R_L1_m_13_45 pixel_13 l1_msum_45 1000000
R_L1_m_14_45 pixel_14 l1_msum_45 137254.90196078431
R_L1_m_15_45 pixel_15 l1_msum_45 24822.695035460994
R_L1_m_16_45 pixel_16 l1_msum_45 1000000
R_L1_m_17_45 pixel_17 l1_msum_45 1000000
R_L1_m_18_45 pixel_18 l1_msum_45 388888.88888888888
R_L1_m_19_45 pixel_19 l1_msum_45 137254.90196078431
R_L1_m_20_45 pixel_20 l1_msum_45 1000000
R_L1_m_21_45 pixel_21 l1_msum_45 1000000
R_L1_m_22_45 pixel_22 l1_msum_45 1000000
R_L1_m_23_45 pixel_23 l1_msum_45 83333.333333333328
R_L1_m_24_45 pixel_24 l1_msum_45 1000000
R_L1_m_25_45 pixel_25 l1_msum_45 1000000
R_L1_m_26_45 pixel_26 l1_msum_45 1000000
R_L1_m_27_45 pixel_27 l1_msum_45 1000000
R_L1_m_28_45 pixel_28 l1_msum_45 54687.499999999993
R_L1_m_29_45 pixel_29 l1_msum_45 1000000
R_L1_m_30_45 pixel_30 l1_msum_45 175000.00000000003
R_L1_m_31_45 pixel_31 l1_msum_45 40697.674418604649
R_L1_m_32_45 pixel_32 l1_msum_45 137254.90196078431
R_L1_m_33_45 pixel_33 l1_msum_45 1000000
R_L1_m_34_45 pixel_34 l1_msum_45 1000000
R_L1_m_35_45 pixel_35 l1_msum_45 34146.341463414632
R_L1_m_36_45 pixel_36 l1_msum_45 40697.674418604649
R_L1_m_37_45 pixel_37 l1_msum_45 1000000
R_L1_m_38_45 pixel_38 l1_msum_45 1000000
R_L1_m_39_45 pixel_39 l1_msum_45 23890.784982935158
R_L1_m_40_45 pixel_40 l1_msum_45 1000000
R_L1_m_41_45 pixel_41 l1_msum_45 95890.410958904104
R_L1_m_42_45 pixel_42 l1_msum_45 1000000
R_L1_m_43_45 pixel_43 l1_msum_45 1000000
R_L1_m_44_45 pixel_44 l1_msum_45 1000000
R_L1_m_45_45 pixel_45 l1_msum_45 241379.31034482759
R_L1_m_46_45 pixel_46 l1_msum_45 59829.059829059821
R_L1_m_47_45 pixel_47 l1_msum_45 34146.341463414632
R_L1_m_48_45 pixel_48 l1_msum_45 83333.333333333328
R_L1_m_49_45 pixel_49 l1_msum_45 1000000
R_L1_m_50_45 pixel_50 l1_msum_45 1000000
R_L1_m_51_45 pixel_51 l1_msum_45 1000000
R_L1_m_52_45 pixel_52 l1_msum_45 1000000
R_L1_m_53_45 pixel_53 l1_msum_45 34146.341463414632
R_L1_m_54_45 pixel_54 l1_msum_45 25830.258302583028
R_L1_m_55_45 pixel_55 l1_msum_45 73684.210526315786
R_L1_m_56_45 pixel_56 l1_msum_45 1000000
R_L1_m_57_45 pixel_57 l1_msum_45 1000000
R_L1_m_58_45 pixel_58 l1_msum_45 1000000
R_L1_m_59_45 pixel_59 l1_msum_45 1000000
R_L1_m_60_45 pixel_60 l1_msum_45 73684.210526315786
R_L1_m_61_45 pixel_61 l1_msum_45 112903.22580645159
R_L1_m_62_45 pixel_62 l1_msum_45 1000000
R_L1_m_63_45 pixel_63 l1_msum_45 137254.90196078431
E_TIA_L1_m_45 l1_mout_45 0 0 l1_msum_45 100000000
R_FB_L1_m_45 l1_mout_45 l1_msum_45 1000
B_NEURON_L1_45 hidden_45 0 V={0.01*max(((V(l1_mout_45)-V(l1_pout_45))/0.0030903275574088963+(0.052535153925418854)),0)}
R_L1_p_0_46 pixel_0 l1_psum_46 38251.366120218576
R_L1_p_1_46 pixel_1 l1_psum_46 175000.00000000003
R_L1_p_2_46 pixel_2 l1_psum_46 59829.059829059821
R_L1_p_3_46 pixel_3 l1_psum_46 95890.410958904104
R_L1_p_4_46 pixel_4 l1_psum_46 175000.00000000003
R_L1_p_5_46 pixel_5 l1_psum_46 1000000
R_L1_p_6_46 pixel_6 l1_psum_46 112903.22580645159
R_L1_p_7_46 pixel_7 l1_psum_46 1000000
R_L1_p_8_46 pixel_8 l1_psum_46 1000000
R_L1_p_9_46 pixel_9 l1_psum_46 1000000
R_L1_p_10_46 pixel_10 l1_psum_46 1000000
R_L1_p_11_46 pixel_11 l1_psum_46 1000000
R_L1_p_12_46 pixel_12 l1_psum_46 59829.059829059821
R_L1_p_13_46 pixel_13 l1_psum_46 66037.735849056597
R_L1_p_14_46 pixel_14 l1_psum_46 1000000
R_L1_p_15_46 pixel_15 l1_psum_46 1000000
R_L1_p_16_46 pixel_16 l1_psum_46 1000000
R_L1_p_17_46 pixel_17 l1_psum_46 1000000
R_L1_p_18_46 pixel_18 l1_psum_46 388888.88888888888
R_L1_p_19_46 pixel_19 l1_psum_46 388888.88888888888
R_L1_p_20_46 pixel_20 l1_psum_46 83333.333333333328
R_L1_p_21_46 pixel_21 l1_psum_46 54687.499999999993
R_L1_p_22_46 pixel_22 l1_psum_46 1000000
R_L1_p_23_46 pixel_23 l1_psum_46 1000000
R_L1_p_24_46 pixel_24 l1_psum_46 1000000
R_L1_p_25_46 pixel_25 l1_psum_46 175000.00000000003
R_L1_p_26_46 pixel_26 l1_psum_46 73684.210526315786
R_L1_p_27_46 pixel_27 l1_psum_46 1000000
R_L1_p_28_46 pixel_28 l1_psum_46 1000000
R_L1_p_29_46 pixel_29 l1_psum_46 54687.499999999993
R_L1_p_30_46 pixel_30 l1_psum_46 59829.059829059821
R_L1_p_31_46 pixel_31 l1_psum_46 1000000
R_L1_p_32_46 pixel_32 l1_psum_46 1000000
R_L1_p_33_46 pixel_33 l1_psum_46 95890.410958904104
R_L1_p_34_46 pixel_34 l1_psum_46 83333.333333333328
R_L1_p_35_46 pixel_35 l1_psum_46 1000000
R_L1_p_36_46 pixel_36 l1_psum_46 1000000
R_L1_p_37_46 pixel_37 l1_psum_46 83333.333333333328
R_L1_p_38_46 pixel_38 l1_psum_46 1000000
R_L1_p_39_46 pixel_39 l1_psum_46 1000000
R_L1_p_40_46 pixel_40 l1_psum_46 1000000
R_L1_p_41_46 pixel_41 l1_psum_46 1000000
R_L1_p_42_46 pixel_42 l1_psum_46 175000.00000000003
R_L1_p_43_46 pixel_43 l1_psum_46 54687.499999999993
R_L1_p_44_46 pixel_44 l1_psum_46 388888.88888888888
R_L1_p_45_46 pixel_45 l1_psum_46 1000000
R_L1_p_46_46 pixel_46 l1_psum_46 1000000
R_L1_p_47_46 pixel_47 l1_psum_46 388888.88888888888
R_L1_p_48_46 pixel_48 l1_psum_46 1000000
R_L1_p_49_46 pixel_49 l1_psum_46 388888.88888888888
R_L1_p_50_46 pixel_50 l1_psum_46 137254.90196078431
R_L1_p_51_46 pixel_51 l1_psum_46 73684.210526315786
R_L1_p_52_46 pixel_52 l1_psum_46 66037.735849056597
R_L1_p_53_46 pixel_53 l1_psum_46 1000000
R_L1_p_54_46 pixel_54 l1_psum_46 1000000
R_L1_p_55_46 pixel_55 l1_psum_46 1000000
R_L1_p_56_46 pixel_56 l1_psum_46 66037.735849056597
R_L1_p_57_46 pixel_57 l1_psum_46 175000.00000000003
R_L1_p_58_46 pixel_58 l1_psum_46 1000000
R_L1_p_59_46 pixel_59 l1_psum_46 1000000
R_L1_p_60_46 pixel_60 l1_psum_46 1000000
R_L1_p_61_46 pixel_61 l1_psum_46 34146.341463414632
R_L1_p_62_46 pixel_62 l1_psum_46 32407.407407407409
R_L1_p_63_46 pixel_63 l1_psum_46 83333.333333333328
E_TIA_L1_p_46 l1_pout_46 0 0 l1_psum_46 100000000
R_FB_L1_p_46 l1_pout_46 l1_psum_46 1000
R_L1_m_0_46 pixel_0 l1_msum_46 1000000
R_L1_m_1_46 pixel_1 l1_msum_46 1000000
R_L1_m_2_46 pixel_2 l1_msum_46 1000000
R_L1_m_3_46 pixel_3 l1_msum_46 1000000
R_L1_m_4_46 pixel_4 l1_msum_46 1000000
R_L1_m_5_46 pixel_5 l1_msum_46 1000000
R_L1_m_6_46 pixel_6 l1_msum_46 1000000
R_L1_m_7_46 pixel_7 l1_msum_46 54687.499999999993
R_L1_m_8_46 pixel_8 l1_msum_46 95890.410958904104
R_L1_m_9_46 pixel_9 l1_msum_46 388888.88888888888
R_L1_m_10_46 pixel_10 l1_msum_46 54687.499999999993
R_L1_m_11_46 pixel_11 l1_msum_46 137254.90196078431
R_L1_m_12_46 pixel_12 l1_msum_46 1000000
R_L1_m_13_46 pixel_13 l1_msum_46 1000000
R_L1_m_14_46 pixel_14 l1_msum_46 43478.260869565216
R_L1_m_15_46 pixel_15 l1_msum_46 14256.619144602852
R_L1_m_16_46 pixel_16 l1_msum_46 50359.712230215831
R_L1_m_17_46 pixel_17 l1_msum_46 112903.22580645159
R_L1_m_18_46 pixel_18 l1_msum_46 1000000
R_L1_m_19_46 pixel_19 l1_msum_46 1000000
R_L1_m_20_46 pixel_20 l1_msum_46 1000000
R_L1_m_21_46 pixel_21 l1_msum_46 1000000
R_L1_m_22_46 pixel_22 l1_msum_46 388888.88888888888
R_L1_m_23_46 pixel_23 l1_msum_46 17857.142857142859
R_L1_m_24_46 pixel_24 l1_msum_46 241379.31034482759
R_L1_m_25_46 pixel_25 l1_msum_46 1000000
R_L1_m_26_46 pixel_26 l1_msum_46 1000000
R_L1_m_27_46 pixel_27 l1_msum_46 112903.22580645159
R_L1_m_28_46 pixel_28 l1_msum_46 34146.341463414632
R_L1_m_29_46 pixel_29 l1_msum_46 1000000
R_L1_m_30_46 pixel_30 l1_msum_46 1000000
R_L1_m_31_46 pixel_31 l1_msum_46 30837.004405286345
R_L1_m_32_46 pixel_32 l1_msum_46 43478.260869565216
R_L1_m_33_46 pixel_33 l1_msum_46 1000000
R_L1_m_34_46 pixel_34 l1_msum_46 1000000
R_L1_m_35_46 pixel_35 l1_msum_46 83333.333333333328
R_L1_m_36_46 pixel_36 l1_msum_46 59829.059829059821
R_L1_m_37_46 pixel_37 l1_msum_46 1000000
R_L1_m_38_46 pixel_38 l1_msum_46 66037.735849056597
R_L1_m_39_46 pixel_39 l1_msum_46 66037.735849056597
R_L1_m_40_46 pixel_40 l1_msum_46 137254.90196078431
R_L1_m_41_46 pixel_41 l1_msum_46 112903.22580645159
R_L1_m_42_46 pixel_42 l1_msum_46 1000000
R_L1_m_43_46 pixel_43 l1_msum_46 1000000
R_L1_m_44_46 pixel_44 l1_msum_46 1000000
R_L1_m_45_46 pixel_45 l1_msum_46 175000.00000000003
R_L1_m_46_46 pixel_46 l1_msum_46 66037.735849056597
R_L1_m_47_46 pixel_47 l1_msum_46 1000000
R_L1_m_48_46 pixel_48 l1_msum_46 388888.88888888888
R_L1_m_49_46 pixel_49 l1_msum_46 1000000
R_L1_m_50_46 pixel_50 l1_msum_46 1000000
R_L1_m_51_46 pixel_51 l1_msum_46 1000000
R_L1_m_52_46 pixel_52 l1_msum_46 1000000
R_L1_m_53_46 pixel_53 l1_msum_46 137254.90196078431
R_L1_m_54_46 pixel_54 l1_msum_46 50359.712230215831
R_L1_m_55_46 pixel_55 l1_msum_46 241379.31034482759
R_L1_m_56_46 pixel_56 l1_msum_46 1000000
R_L1_m_57_46 pixel_57 l1_msum_46 1000000
R_L1_m_58_46 pixel_58 l1_msum_46 112903.22580645159
R_L1_m_59_46 pixel_59 l1_msum_46 43478.260869565216
R_L1_m_60_46 pixel_60 l1_msum_46 1000000
R_L1_m_61_46 pixel_61 l1_msum_46 1000000
R_L1_m_62_46 pixel_62 l1_msum_46 1000000
R_L1_m_63_46 pixel_63 l1_msum_46 1000000
E_TIA_L1_m_46 l1_mout_46 0 0 l1_msum_46 100000000
R_FB_L1_m_46 l1_mout_46 l1_msum_46 1000
B_NEURON_L1_46 hidden_46 0 V={0.01*max(((V(l1_mout_46)-V(l1_pout_46))/0.0030903275574088963+(-0.1547723114490509)),0)}
R_L1_p_0_47 pixel_0 l1_psum_47 95890.410958904104
R_L1_p_1_47 pixel_1 l1_psum_47 1000000
R_L1_p_2_47 pixel_2 l1_psum_47 1000000
R_L1_p_3_47 pixel_3 l1_psum_47 1000000
R_L1_p_4_47 pixel_4 l1_psum_47 1000000
R_L1_p_5_47 pixel_5 l1_psum_47 1000000
R_L1_p_6_47 pixel_6 l1_psum_47 1000000
R_L1_p_7_47 pixel_7 l1_psum_47 1000000
R_L1_p_8_47 pixel_8 l1_psum_47 1000000
R_L1_p_9_47 pixel_9 l1_psum_47 1000000
R_L1_p_10_47 pixel_10 l1_psum_47 1000000
R_L1_p_11_47 pixel_11 l1_psum_47 388888.88888888888
R_L1_p_12_47 pixel_12 l1_psum_47 1000000
R_L1_p_13_47 pixel_13 l1_psum_47 1000000
R_L1_p_14_47 pixel_14 l1_psum_47 1000000
R_L1_p_15_47 pixel_15 l1_psum_47 175000.00000000003
R_L1_p_16_47 pixel_16 l1_psum_47 112903.22580645159
R_L1_p_17_47 pixel_17 l1_psum_47 1000000
R_L1_p_18_47 pixel_18 l1_psum_47 112903.22580645159
R_L1_p_19_47 pixel_19 l1_psum_47 36082.474226804123
R_L1_p_20_47 pixel_20 l1_psum_47 388888.88888888888
R_L1_p_21_47 pixel_21 l1_psum_47 95890.410958904104
R_L1_p_22_47 pixel_22 l1_psum_47 40697.674418604649
R_L1_p_23_47 pixel_23 l1_psum_47 34146.341463414632
R_L1_p_24_47 pixel_24 l1_psum_47 46666.666666666664
R_L1_p_25_47 pixel_25 l1_psum_47 137254.90196078431
R_L1_p_26_47 pixel_26 l1_psum_47 1000000
R_L1_p_27_47 pixel_27 l1_psum_47 112903.22580645159
R_L1_p_28_47 pixel_28 l1_psum_47 1000000
R_L1_p_29_47 pixel_29 l1_psum_47 1000000
R_L1_p_30_47 pixel_30 l1_psum_47 241379.31034482759
R_L1_p_31_47 pixel_31 l1_psum_47 95890.410958904104
R_L1_p_32_47 pixel_32 l1_psum_47 1000000
R_L1_p_33_47 pixel_33 l1_psum_47 66037.735849056597
R_L1_p_34_47 pixel_34 l1_psum_47 23890.784982935158
R_L1_p_35_47 pixel_35 l1_psum_47 1000000
R_L1_p_36_47 pixel_36 l1_psum_47 1000000
R_L1_p_37_47 pixel_37 l1_psum_47 137254.90196078431
R_L1_p_38_47 pixel_38 l1_psum_47 112903.22580645159
R_L1_p_39_47 pixel_39 l1_psum_47 1000000
R_L1_p_40_47 pixel_40 l1_psum_47 1000000
R_L1_p_41_47 pixel_41 l1_psum_47 73684.210526315786
R_L1_p_42_47 pixel_42 l1_psum_47 73684.210526315786
R_L1_p_43_47 pixel_43 l1_psum_47 1000000
R_L1_p_44_47 pixel_44 l1_psum_47 1000000
R_L1_p_45_47 pixel_45 l1_psum_47 1000000
R_L1_p_46_47 pixel_46 l1_psum_47 241379.31034482759
R_L1_p_47_47 pixel_47 l1_psum_47 1000000
R_L1_p_48_47 pixel_48 l1_psum_47 1000000
R_L1_p_49_47 pixel_49 l1_psum_47 59829.059829059821
R_L1_p_50_47 pixel_50 l1_psum_47 54687.499999999993
R_L1_p_51_47 pixel_51 l1_psum_47 59829.059829059821
R_L1_p_52_47 pixel_52 l1_psum_47 1000000
R_L1_p_53_47 pixel_53 l1_psum_47 1000000
R_L1_p_54_47 pixel_54 l1_psum_47 1000000
R_L1_p_55_47 pixel_55 l1_psum_47 1000000
R_L1_p_56_47 pixel_56 l1_psum_47 73684.210526315786
R_L1_p_57_47 pixel_57 l1_psum_47 1000000
R_L1_p_58_47 pixel_58 l1_psum_47 1000000
R_L1_p_59_47 pixel_59 l1_psum_47 59829.059829059821
R_L1_p_60_47 pixel_60 l1_psum_47 1000000
R_L1_p_61_47 pixel_61 l1_psum_47 1000000
R_L1_p_62_47 pixel_62 l1_psum_47 1000000
R_L1_p_63_47 pixel_63 l1_psum_47 112903.22580645159
E_TIA_L1_p_47 l1_pout_47 0 0 l1_psum_47 100000000
R_FB_L1_p_47 l1_pout_47 l1_psum_47 1000
R_L1_m_0_47 pixel_0 l1_msum_47 1000000
R_L1_m_1_47 pixel_1 l1_msum_47 36082.474226804123
R_L1_m_2_47 pixel_2 l1_msum_47 23026.315789473687
R_L1_m_3_47 pixel_3 l1_msum_47 20114.942528735632
R_L1_m_4_47 pixel_4 l1_msum_47 23890.784982935158
R_L1_m_5_47 pixel_5 l1_msum_47 43478.260869565216
R_L1_m_6_47 pixel_6 l1_msum_47 83333.333333333328
R_L1_m_7_47 pixel_7 l1_msum_47 59829.059829059821
R_L1_m_8_47 pixel_8 l1_msum_47 43478.260869565216
R_L1_m_9_47 pixel_9 l1_msum_47 66037.735849056597
R_L1_m_10_47 pixel_10 l1_msum_47 36082.474226804123
R_L1_m_11_47 pixel_11 l1_msum_47 1000000
R_L1_m_12_47 pixel_12 l1_msum_47 1000000
R_L1_m_13_47 pixel_13 l1_msum_47 137254.90196078431
R_L1_m_14_47 pixel_14 l1_msum_47 388888.88888888888
R_L1_m_15_47 pixel_15 l1_msum_47 1000000
R_L1_m_16_47 pixel_16 l1_msum_47 1000000
R_L1_m_17_47 pixel_17 l1_msum_47 54687.499999999993
R_L1_m_18_47 pixel_18 l1_msum_47 1000000
R_L1_m_19_47 pixel_19 l1_msum_47 1000000
R_L1_m_20_47 pixel_20 l1_msum_47 1000000
R_L1_m_21_47 pixel_21 l1_msum_47 1000000
R_L1_m_22_47 pixel_22 l1_msum_47 1000000
R_L1_m_23_47 pixel_23 l1_msum_47 1000000
R_L1_m_24_47 pixel_24 l1_msum_47 1000000
R_L1_m_25_47 pixel_25 l1_msum_47 1000000
R_L1_m_26_47 pixel_26 l1_msum_47 1000000
R_L1_m_27_47 pixel_27 l1_msum_47 1000000
R_L1_m_28_47 pixel_28 l1_msum_47 38251.366120218576
R_L1_m_29_47 pixel_29 l1_msum_47 388888.88888888888
R_L1_m_30_47 pixel_30 l1_msum_47 1000000
R_L1_m_31_47 pixel_31 l1_msum_47 1000000
R_L1_m_32_47 pixel_32 l1_msum_47 34146.341463414632
R_L1_m_33_47 pixel_33 l1_msum_47 1000000
R_L1_m_34_47 pixel_34 l1_msum_47 1000000
R_L1_m_35_47 pixel_35 l1_msum_47 73684.210526315786
R_L1_m_36_47 pixel_36 l1_msum_47 50359.712230215831
R_L1_m_37_47 pixel_37 l1_msum_47 1000000
R_L1_m_38_47 pixel_38 l1_msum_47 1000000
R_L1_m_39_47 pixel_39 l1_msum_47 137254.90196078431
R_L1_m_40_47 pixel_40 l1_msum_47 95890.410958904104
R_L1_m_41_47 pixel_41 l1_msum_47 1000000
R_L1_m_42_47 pixel_42 l1_msum_47 1000000
R_L1_m_43_47 pixel_43 l1_msum_47 175000.00000000003
R_L1_m_44_47 pixel_44 l1_msum_47 73684.210526315786
R_L1_m_45_47 pixel_45 l1_msum_47 137254.90196078431
R_L1_m_46_47 pixel_46 l1_msum_47 1000000
R_L1_m_47_47 pixel_47 l1_msum_47 19498.607242339833
R_L1_m_48_47 pixel_48 l1_msum_47 95890.410958904104
R_L1_m_49_47 pixel_49 l1_msum_47 1000000
R_L1_m_50_47 pixel_50 l1_msum_47 1000000
R_L1_m_51_47 pixel_51 l1_msum_47 1000000
R_L1_m_52_47 pixel_52 l1_msum_47 95890.410958904104
R_L1_m_53_47 pixel_53 l1_msum_47 59829.059829059821
R_L1_m_54_47 pixel_54 l1_msum_47 43478.260869565216
R_L1_m_55_47 pixel_55 l1_msum_47 36082.474226804123
R_L1_m_56_47 pixel_56 l1_msum_47 1000000
R_L1_m_57_47 pixel_57 l1_msum_47 112903.22580645159
R_L1_m_58_47 pixel_58 l1_msum_47 43478.260869565216
R_L1_m_59_47 pixel_59 l1_msum_47 1000000
R_L1_m_60_47 pixel_60 l1_msum_47 388888.88888888888
R_L1_m_61_47 pixel_61 l1_msum_47 36082.474226804123
R_L1_m_62_47 pixel_62 l1_msum_47 66037.735849056597
R_L1_m_63_47 pixel_63 l1_msum_47 1000000
E_TIA_L1_m_47 l1_mout_47 0 0 l1_msum_47 100000000
R_FB_L1_m_47 l1_mout_47 l1_msum_47 1000
B_NEURON_L1_47 hidden_47 0 V={0.01*max(((V(l1_mout_47)-V(l1_pout_47))/0.0030903275574088963+(0.07719043642282486)),0)}
R_L1_p_0_48 pixel_0 l1_psum_48 1000000
R_L1_p_1_48 pixel_1 l1_psum_48 388888.88888888888
R_L1_p_2_48 pixel_2 l1_psum_48 137254.90196078431
R_L1_p_3_48 pixel_3 l1_psum_48 1000000
R_L1_p_4_48 pixel_4 l1_psum_48 1000000
R_L1_p_5_48 pixel_5 l1_psum_48 1000000
R_L1_p_6_48 pixel_6 l1_psum_48 1000000
R_L1_p_7_48 pixel_7 l1_psum_48 36082.474226804123
R_L1_p_8_48 pixel_8 l1_psum_48 43478.260869565216
R_L1_p_9_48 pixel_9 l1_psum_48 1000000
R_L1_p_10_48 pixel_10 l1_psum_48 1000000
R_L1_p_11_48 pixel_11 l1_psum_48 1000000
R_L1_p_12_48 pixel_12 l1_psum_48 1000000
R_L1_p_13_48 pixel_13 l1_psum_48 241379.31034482759
R_L1_p_14_48 pixel_14 l1_psum_48 38251.366120218576
R_L1_p_15_48 pixel_15 l1_psum_48 1000000
R_L1_p_16_48 pixel_16 l1_psum_48 1000000
R_L1_p_17_48 pixel_17 l1_psum_48 137254.90196078431
R_L1_p_18_48 pixel_18 l1_psum_48 38251.366120218576
R_L1_p_19_48 pixel_19 l1_psum_48 137254.90196078431
R_L1_p_20_48 pixel_20 l1_psum_48 43478.260869565216
R_L1_p_21_48 pixel_21 l1_psum_48 241379.31034482759
R_L1_p_22_48 pixel_22 l1_psum_48 1000000
R_L1_p_23_48 pixel_23 l1_psum_48 1000000
R_L1_p_24_48 pixel_24 l1_psum_48 1000000
R_L1_p_25_48 pixel_25 l1_psum_48 46666.666666666664
R_L1_p_26_48 pixel_26 l1_psum_48 1000000
R_L1_p_27_48 pixel_27 l1_psum_48 1000000
R_L1_p_28_48 pixel_28 l1_psum_48 241379.31034482759
R_L1_p_29_48 pixel_29 l1_psum_48 1000000
R_L1_p_30_48 pixel_30 l1_psum_48 1000000
R_L1_p_31_48 pixel_31 l1_psum_48 1000000
R_L1_p_32_48 pixel_32 l1_psum_48 1000000
R_L1_p_33_48 pixel_33 l1_psum_48 1000000
R_L1_p_34_48 pixel_34 l1_psum_48 1000000
R_L1_p_35_48 pixel_35 l1_psum_48 1000000
R_L1_p_36_48 pixel_36 l1_psum_48 1000000
R_L1_p_37_48 pixel_37 l1_psum_48 1000000
R_L1_p_38_48 pixel_38 l1_psum_48 1000000
R_L1_p_39_48 pixel_39 l1_psum_48 137254.90196078431
R_L1_p_40_48 pixel_40 l1_psum_48 1000000
R_L1_p_41_48 pixel_41 l1_psum_48 137254.90196078431
R_L1_p_42_48 pixel_42 l1_psum_48 38251.366120218576
R_L1_p_43_48 pixel_43 l1_psum_48 43478.260869565216
R_L1_p_44_48 pixel_44 l1_psum_48 1000000
R_L1_p_45_48 pixel_45 l1_psum_48 1000000
R_L1_p_46_48 pixel_46 l1_psum_48 95890.410958904104
R_L1_p_47_48 pixel_47 l1_psum_48 175000.00000000003
R_L1_p_48_48 pixel_48 l1_psum_48 112903.22580645159
R_L1_p_49_48 pixel_49 l1_psum_48 38251.366120218576
R_L1_p_50_48 pixel_50 l1_psum_48 137254.90196078431
R_L1_p_51_48 pixel_51 l1_psum_48 175000.00000000003
R_L1_p_52_48 pixel_52 l1_psum_48 112903.22580645159
R_L1_p_53_48 pixel_53 l1_psum_48 112903.22580645159
R_L1_p_54_48 pixel_54 l1_psum_48 175000.00000000003
R_L1_p_55_48 pixel_55 l1_psum_48 36082.474226804123
R_L1_p_56_48 pixel_56 l1_psum_48 175000.00000000003
R_L1_p_57_48 pixel_57 l1_psum_48 1000000
R_L1_p_58_48 pixel_58 l1_psum_48 1000000
R_L1_p_59_48 pixel_59 l1_psum_48 137254.90196078431
R_L1_p_60_48 pixel_60 l1_psum_48 54687.499999999993
R_L1_p_61_48 pixel_61 l1_psum_48 1000000
R_L1_p_62_48 pixel_62 l1_psum_48 1000000
R_L1_p_63_48 pixel_63 l1_psum_48 1000000
E_TIA_L1_p_48 l1_pout_48 0 0 l1_psum_48 100000000
R_FB_L1_p_48 l1_pout_48 l1_psum_48 1000
R_L1_m_0_48 pixel_0 l1_msum_48 1000000
R_L1_m_1_48 pixel_1 l1_msum_48 1000000
R_L1_m_2_48 pixel_2 l1_msum_48 1000000
R_L1_m_3_48 pixel_3 l1_msum_48 1000000
R_L1_m_4_48 pixel_4 l1_msum_48 1000000
R_L1_m_5_48 pixel_5 l1_msum_48 54687.499999999993
R_L1_m_6_48 pixel_6 l1_msum_48 43478.260869565216
R_L1_m_7_48 pixel_7 l1_msum_48 1000000
R_L1_m_8_48 pixel_8 l1_msum_48 1000000
R_L1_m_9_48 pixel_9 l1_msum_48 112903.22580645159
R_L1_m_10_48 pixel_10 l1_msum_48 73684.210526315786
R_L1_m_11_48 pixel_11 l1_msum_48 83333.333333333328
R_L1_m_12_48 pixel_12 l1_msum_48 1000000
R_L1_m_13_48 pixel_13 l1_msum_48 1000000
R_L1_m_14_48 pixel_14 l1_msum_48 1000000
R_L1_m_15_48 pixel_15 l1_msum_48 112903.22580645159
R_L1_m_16_48 pixel_16 l1_msum_48 137254.90196078431
R_L1_m_17_48 pixel_17 l1_msum_48 1000000
R_L1_m_18_48 pixel_18 l1_msum_48 1000000
R_L1_m_19_48 pixel_19 l1_msum_48 1000000
R_L1_m_20_48 pixel_20 l1_msum_48 1000000
R_L1_m_21_48 pixel_21 l1_msum_48 1000000
R_L1_m_22_48 pixel_22 l1_msum_48 175000.00000000003
R_L1_m_23_48 pixel_23 l1_msum_48 16055.045871559634
R_L1_m_24_48 pixel_24 l1_msum_48 66037.735849056597
R_L1_m_25_48 pixel_25 l1_msum_48 1000000
R_L1_m_26_48 pixel_26 l1_msum_48 95890.410958904104
R_L1_m_27_48 pixel_27 l1_msum_48 23890.784982935158
R_L1_m_28_48 pixel_28 l1_msum_48 1000000
R_L1_m_29_48 pixel_29 l1_msum_48 388888.88888888888
R_L1_m_30_48 pixel_30 l1_msum_48 54687.499999999993
R_L1_m_31_48 pixel_31 l1_msum_48 73684.210526315786
R_L1_m_32_48 pixel_32 l1_msum_48 18918.91891891892
R_L1_m_33_48 pixel_33 l1_msum_48 15283.842794759827
R_L1_m_34_48 pixel_34 l1_msum_48 23026.315789473687
R_L1_m_35_48 pixel_35 l1_msum_48 241379.31034482759
R_L1_m_36_48 pixel_36 l1_msum_48 83333.333333333328
R_L1_m_37_48 pixel_37 l1_msum_48 73684.210526315786
R_L1_m_38_48 pixel_38 l1_msum_48 388888.88888888888
R_L1_m_39_48 pixel_39 l1_msum_48 1000000
R_L1_m_40_48 pixel_40 l1_msum_48 1000000
R_L1_m_41_48 pixel_41 l1_msum_48 1000000
R_L1_m_42_48 pixel_42 l1_msum_48 1000000
R_L1_m_43_48 pixel_43 l1_msum_48 1000000
R_L1_m_44_48 pixel_44 l1_msum_48 95890.410958904104
R_L1_m_45_48 pixel_45 l1_msum_48 175000.00000000003
R_L1_m_46_48 pixel_46 l1_msum_48 1000000
R_L1_m_47_48 pixel_47 l1_msum_48 1000000
R_L1_m_48_48 pixel_48 l1_msum_48 1000000
R_L1_m_49_48 pixel_49 l1_msum_48 1000000
R_L1_m_50_48 pixel_50 l1_msum_48 1000000
R_L1_m_51_48 pixel_51 l1_msum_48 1000000
R_L1_m_52_48 pixel_52 l1_msum_48 1000000
R_L1_m_53_48 pixel_53 l1_msum_48 1000000
R_L1_m_54_48 pixel_54 l1_msum_48 1000000
R_L1_m_55_48 pixel_55 l1_msum_48 1000000
R_L1_m_56_48 pixel_56 l1_msum_48 1000000
R_L1_m_57_48 pixel_57 l1_msum_48 175000.00000000003
R_L1_m_58_48 pixel_58 l1_msum_48 1000000
R_L1_m_59_48 pixel_59 l1_msum_48 1000000
R_L1_m_60_48 pixel_60 l1_msum_48 1000000
R_L1_m_61_48 pixel_61 l1_msum_48 40697.674418604649
R_L1_m_62_48 pixel_62 l1_msum_48 43478.260869565216
R_L1_m_63_48 pixel_63 l1_msum_48 1000000
E_TIA_L1_m_48 l1_mout_48 0 0 l1_msum_48 100000000
R_FB_L1_m_48 l1_mout_48 l1_msum_48 1000
B_NEURON_L1_48 hidden_48 0 V={0.01*max(((V(l1_mout_48)-V(l1_pout_48))/0.0030903275574088963+(0.091307669878005981)),0)}
R_L1_p_0_49 pixel_0 l1_psum_49 241379.31034482759
R_L1_p_1_49 pixel_1 l1_psum_49 241379.31034482759
R_L1_p_2_49 pixel_2 l1_psum_49 38251.366120218576
R_L1_p_3_49 pixel_3 l1_psum_49 59829.059829059821
R_L1_p_4_49 pixel_4 l1_psum_49 1000000
R_L1_p_5_49 pixel_5 l1_psum_49 22222.222222222223
R_L1_p_6_49 pixel_6 l1_psum_49 17369.727047146403
R_L1_p_7_49 pixel_7 l1_psum_49 95890.410958904104
R_L1_p_8_49 pixel_8 l1_psum_49 40697.674418604649
R_L1_p_9_49 pixel_9 l1_psum_49 95890.410958904104
R_L1_p_10_49 pixel_10 l1_psum_49 388888.88888888888
R_L1_p_11_49 pixel_11 l1_psum_49 1000000
R_L1_p_12_49 pixel_12 l1_psum_49 1000000
R_L1_p_13_49 pixel_13 l1_psum_49 1000000
R_L1_p_14_49 pixel_14 l1_psum_49 73684.210526315786
R_L1_p_15_49 pixel_15 l1_psum_49 175000.00000000003
R_L1_p_16_49 pixel_16 l1_psum_49 16055.045871559634
R_L1_p_17_49 pixel_17 l1_psum_49 29411.764705882353
R_L1_p_18_49 pixel_18 l1_psum_49 23890.784982935158
R_L1_p_19_49 pixel_19 l1_psum_49 34146.341463414632
R_L1_p_20_49 pixel_20 l1_psum_49 73684.210526315786
R_L1_p_21_49 pixel_21 l1_psum_49 59829.059829059821
R_L1_p_22_49 pixel_22 l1_psum_49 34146.341463414632
R_L1_p_23_49 pixel_23 l1_psum_49 1000000
R_L1_p_24_49 pixel_24 l1_psum_49 1000000
R_L1_p_25_49 pixel_25 l1_psum_49 1000000
R_L1_p_26_49 pixel_26 l1_psum_49 1000000
R_L1_p_27_49 pixel_27 l1_psum_49 1000000
R_L1_p_28_49 pixel_28 l1_psum_49 1000000
R_L1_p_29_49 pixel_29 l1_psum_49 1000000
R_L1_p_30_49 pixel_30 l1_psum_49 1000000
R_L1_p_31_49 pixel_31 l1_psum_49 1000000
R_L1_p_32_49 pixel_32 l1_psum_49 1000000
R_L1_p_33_49 pixel_33 l1_psum_49 1000000
R_L1_p_34_49 pixel_34 l1_psum_49 1000000
R_L1_p_35_49 pixel_35 l1_psum_49 95890.410958904104
R_L1_p_36_49 pixel_36 l1_psum_49 388888.88888888888
R_L1_p_37_49 pixel_37 l1_psum_49 175000.00000000003
R_L1_p_38_49 pixel_38 l1_psum_49 1000000
R_L1_p_39_49 pixel_39 l1_psum_49 73684.210526315786
R_L1_p_40_49 pixel_40 l1_psum_49 29411.764705882353
R_L1_p_41_49 pixel_41 l1_psum_49 36082.474226804123
R_L1_p_42_49 pixel_42 l1_psum_49 175000.00000000003
R_L1_p_43_49 pixel_43 l1_psum_49 388888.88888888888
R_L1_p_44_49 pixel_44 l1_psum_49 175000.00000000003
R_L1_p_45_49 pixel_45 l1_psum_49 112903.22580645159
R_L1_p_46_49 pixel_46 l1_psum_49 1000000
R_L1_p_47_49 pixel_47 l1_psum_49 1000000
R_L1_p_48_49 pixel_48 l1_psum_49 66037.735849056597
R_L1_p_49_49 pixel_49 l1_psum_49 388888.88888888888
R_L1_p_50_49 pixel_50 l1_psum_49 112903.22580645159
R_L1_p_51_49 pixel_51 l1_psum_49 137254.90196078431
R_L1_p_52_49 pixel_52 l1_psum_49 73684.210526315786
R_L1_p_53_49 pixel_53 l1_psum_49 1000000
R_L1_p_54_49 pixel_54 l1_psum_49 1000000
R_L1_p_55_49 pixel_55 l1_psum_49 1000000
R_L1_p_56_49 pixel_56 l1_psum_49 66037.735849056597
R_L1_p_57_49 pixel_57 l1_psum_49 66037.735849056597
R_L1_p_58_49 pixel_58 l1_psum_49 40697.674418604649
R_L1_p_59_49 pixel_59 l1_psum_49 66037.735849056597
R_L1_p_60_49 pixel_60 l1_psum_49 43478.260869565216
R_L1_p_61_49 pixel_61 l1_psum_49 32407.407407407409
R_L1_p_62_49 pixel_62 l1_psum_49 1000000
R_L1_p_63_49 pixel_63 l1_psum_49 1000000
E_TIA_L1_p_49 l1_pout_49 0 0 l1_psum_49 100000000
R_FB_L1_p_49 l1_pout_49 l1_psum_49 1000
R_L1_m_0_49 pixel_0 l1_msum_49 1000000
R_L1_m_1_49 pixel_1 l1_msum_49 1000000
R_L1_m_2_49 pixel_2 l1_msum_49 1000000
R_L1_m_3_49 pixel_3 l1_msum_49 1000000
R_L1_m_4_49 pixel_4 l1_msum_49 43478.260869565216
R_L1_m_5_49 pixel_5 l1_msum_49 1000000
R_L1_m_6_49 pixel_6 l1_msum_49 1000000
R_L1_m_7_49 pixel_7 l1_msum_49 1000000
R_L1_m_8_49 pixel_8 l1_msum_49 1000000
R_L1_m_9_49 pixel_9 l1_msum_49 1000000
R_L1_m_10_49 pixel_10 l1_msum_49 1000000
R_L1_m_11_49 pixel_11 l1_msum_49 66037.735849056597
R_L1_m_12_49 pixel_12 l1_msum_49 241379.31034482759
R_L1_m_13_49 pixel_13 l1_msum_49 388888.88888888888
R_L1_m_14_49 pixel_14 l1_msum_49 1000000
R_L1_m_15_49 pixel_15 l1_msum_49 1000000
R_L1_m_16_49 pixel_16 l1_msum_49 1000000
R_L1_m_17_49 pixel_17 l1_msum_49 1000000
R_L1_m_18_49 pixel_18 l1_msum_49 1000000
R_L1_m_19_49 pixel_19 l1_msum_49 1000000
R_L1_m_20_49 pixel_20 l1_msum_49 1000000
R_L1_m_21_49 pixel_21 l1_msum_49 1000000
R_L1_m_22_49 pixel_22 l1_msum_49 1000000
R_L1_m_23_49 pixel_23 l1_msum_49 1000000
R_L1_m_24_49 pixel_24 l1_msum_49 50359.712230215831
R_L1_m_25_49 pixel_25 l1_msum_49 26923.076923076922
R_L1_m_26_49 pixel_26 l1_msum_49 25830.258302583028
R_L1_m_27_49 pixel_27 l1_msum_49 25830.258302583028
R_L1_m_28_49 pixel_28 l1_msum_49 73684.210526315786
R_L1_m_29_49 pixel_29 l1_msum_49 73684.210526315786
R_L1_m_30_49 pixel_30 l1_msum_49 22222.222222222223
R_L1_m_31_49 pixel_31 l1_msum_49 66037.735849056597
R_L1_m_32_49 pixel_32 l1_msum_49 73684.210526315786
R_L1_m_33_49 pixel_33 l1_msum_49 30837.004405286345
R_L1_m_34_49 pixel_34 l1_msum_49 46666.666666666664
R_L1_m_35_49 pixel_35 l1_msum_49 1000000
R_L1_m_36_49 pixel_36 l1_msum_49 1000000
R_L1_m_37_49 pixel_37 l1_msum_49 1000000
R_L1_m_38_49 pixel_38 l1_msum_49 1000000
R_L1_m_39_49 pixel_39 l1_msum_49 1000000
R_L1_m_40_49 pixel_40 l1_msum_49 1000000
R_L1_m_41_49 pixel_41 l1_msum_49 1000000
R_L1_m_42_49 pixel_42 l1_msum_49 1000000
R_L1_m_43_49 pixel_43 l1_msum_49 1000000
R_L1_m_44_49 pixel_44 l1_msum_49 1000000
R_L1_m_45_49 pixel_45 l1_msum_49 1000000
R_L1_m_46_49 pixel_46 l1_msum_49 66037.735849056597
R_L1_m_47_49 pixel_47 l1_msum_49 83333.333333333328
R_L1_m_48_49 pixel_48 l1_msum_49 1000000
R_L1_m_49_49 pixel_49 l1_msum_49 1000000
R_L1_m_50_49 pixel_50 l1_msum_49 1000000
R_L1_m_51_49 pixel_51 l1_msum_49 1000000
R_L1_m_52_49 pixel_52 l1_msum_49 1000000
R_L1_m_53_49 pixel_53 l1_msum_49 175000.00000000003
R_L1_m_54_49 pixel_54 l1_msum_49 59829.059829059821
R_L1_m_55_49 pixel_55 l1_msum_49 175000.00000000003
R_L1_m_56_49 pixel_56 l1_msum_49 1000000
R_L1_m_57_49 pixel_57 l1_msum_49 1000000
R_L1_m_58_49 pixel_58 l1_msum_49 1000000
R_L1_m_59_49 pixel_59 l1_msum_49 1000000
R_L1_m_60_49 pixel_60 l1_msum_49 1000000
R_L1_m_61_49 pixel_61 l1_msum_49 1000000
R_L1_m_62_49 pixel_62 l1_msum_49 1000000
R_L1_m_63_49 pixel_63 l1_msum_49 112903.22580645159
E_TIA_L1_m_49 l1_mout_49 0 0 l1_msum_49 100000000
R_FB_L1_m_49 l1_mout_49 l1_msum_49 1000
B_NEURON_L1_49 hidden_49 0 V={0.01*max(((V(l1_mout_49)-V(l1_pout_49))/0.0030903275574088963+(-0.14559558033943176)),0)}
* Layer 2: 50 rows, 20 physical columns, 10 logical outputs
R_L2_p_0_0 hidden_0 l2_psum_0 1000000
R_L2_p_1_0 hidden_1 l2_psum_0 137254.90196078431
R_L2_p_2_0 hidden_2 l2_psum_0 1000000
R_L2_p_3_0 hidden_3 l2_psum_0 1000000
R_L2_p_4_0 hidden_4 l2_psum_0 1000000
R_L2_p_5_0 hidden_5 l2_psum_0 29411.764705882353
R_L2_p_6_0 hidden_6 l2_psum_0 1000000
R_L2_p_7_0 hidden_7 l2_psum_0 83333.333333333328
R_L2_p_8_0 hidden_8 l2_psum_0 38251.366120218576
R_L2_p_9_0 hidden_9 l2_psum_0 1000000
R_L2_p_10_0 hidden_10 l2_psum_0 38251.366120218576
R_L2_p_11_0 hidden_11 l2_psum_0 59829.059829059821
R_L2_p_12_0 hidden_12 l2_psum_0 54687.499999999993
R_L2_p_13_0 hidden_13 l2_psum_0 1000000
R_L2_p_14_0 hidden_14 l2_psum_0 1000000
R_L2_p_15_0 hidden_15 l2_psum_0 241379.31034482759
R_L2_p_16_0 hidden_16 l2_psum_0 95890.410958904104
R_L2_p_17_0 hidden_17 l2_psum_0 1000000
R_L2_p_18_0 hidden_18 l2_psum_0 1000000
R_L2_p_19_0 hidden_19 l2_psum_0 40697.674418604649
R_L2_p_20_0 hidden_20 l2_psum_0 1000000
R_L2_p_21_0 hidden_21 l2_psum_0 1000000
R_L2_p_22_0 hidden_22 l2_psum_0 1000000
R_L2_p_23_0 hidden_23 l2_psum_0 40697.674418604649
R_L2_p_24_0 hidden_24 l2_psum_0 1000000
R_L2_p_25_0 hidden_25 l2_psum_0 1000000
R_L2_p_26_0 hidden_26 l2_psum_0 54687.499999999993
R_L2_p_27_0 hidden_27 l2_psum_0 388888.88888888888
R_L2_p_28_0 hidden_28 l2_psum_0 1000000
R_L2_p_29_0 hidden_29 l2_psum_0 1000000
R_L2_p_30_0 hidden_30 l2_psum_0 1000000
R_L2_p_31_0 hidden_31 l2_psum_0 1000000
R_L2_p_32_0 hidden_32 l2_psum_0 1000000
R_L2_p_33_0 hidden_33 l2_psum_0 1000000
R_L2_p_34_0 hidden_34 l2_psum_0 241379.31034482759
R_L2_p_35_0 hidden_35 l2_psum_0 46666.666666666664
R_L2_p_36_0 hidden_36 l2_psum_0 1000000
R_L2_p_37_0 hidden_37 l2_psum_0 59829.059829059821
R_L2_p_38_0 hidden_38 l2_psum_0 95890.410958904104
R_L2_p_39_0 hidden_39 l2_psum_0 1000000
R_L2_p_40_0 hidden_40 l2_psum_0 1000000
R_L2_p_41_0 hidden_41 l2_psum_0 1000000
R_L2_p_42_0 hidden_42 l2_psum_0 1000000
R_L2_p_43_0 hidden_43 l2_psum_0 1000000
R_L2_p_44_0 hidden_44 l2_psum_0 137254.90196078431
R_L2_p_45_0 hidden_45 l2_psum_0 32407.407407407409
R_L2_p_46_0 hidden_46 l2_psum_0 32407.407407407409
R_L2_p_47_0 hidden_47 l2_psum_0 34146.341463414632
R_L2_p_48_0 hidden_48 l2_psum_0 1000000
R_L2_p_49_0 hidden_49 l2_psum_0 1000000
E_TIA_L2_p_0 l2_pout_0 0 0 l2_psum_0 100000000
R_FB_L2_p_0 l2_pout_0 l2_psum_0 1000
R_L2_m_0_0 hidden_0 l2_msum_0 36082.474226804123
R_L2_m_1_0 hidden_1 l2_msum_0 1000000
R_L2_m_2_0 hidden_2 l2_msum_0 46666.666666666664
R_L2_m_3_0 hidden_3 l2_msum_0 175000.00000000003
R_L2_m_4_0 hidden_4 l2_msum_0 175000.00000000003
R_L2_m_5_0 hidden_5 l2_msum_0 1000000
R_L2_m_6_0 hidden_6 l2_msum_0 46666.666666666664
R_L2_m_7_0 hidden_7 l2_msum_0 1000000
R_L2_m_8_0 hidden_8 l2_msum_0 1000000
R_L2_m_9_0 hidden_9 l2_msum_0 16908.212560386473
R_L2_m_10_0 hidden_10 l2_msum_0 1000000
R_L2_m_11_0 hidden_11 l2_msum_0 1000000
R_L2_m_12_0 hidden_12 l2_msum_0 1000000
R_L2_m_13_0 hidden_13 l2_msum_0 54687.499999999993
R_L2_m_14_0 hidden_14 l2_msum_0 21472.39263803681
R_L2_m_15_0 hidden_15 l2_msum_0 1000000
R_L2_m_16_0 hidden_16 l2_msum_0 1000000
R_L2_m_17_0 hidden_17 l2_msum_0 66037.735849056597
R_L2_m_18_0 hidden_18 l2_msum_0 32407.407407407409
R_L2_m_19_0 hidden_19 l2_msum_0 1000000
R_L2_m_20_0 hidden_20 l2_msum_0 20114.942528735632
R_L2_m_21_0 hidden_21 l2_msum_0 24822.695035460994
R_L2_m_22_0 hidden_22 l2_msum_0 46666.666666666664
R_L2_m_23_0 hidden_23 l2_msum_0 1000000
R_L2_m_24_0 hidden_24 l2_msum_0 95890.410958904104
R_L2_m_25_0 hidden_25 l2_msum_0 38251.366120218576
R_L2_m_26_0 hidden_26 l2_msum_0 1000000
R_L2_m_27_0 hidden_27 l2_msum_0 1000000
R_L2_m_28_0 hidden_28 l2_msum_0 241379.31034482759
R_L2_m_29_0 hidden_29 l2_msum_0 388888.88888888888
R_L2_m_30_0 hidden_30 l2_msum_0 175000.00000000003
R_L2_m_31_0 hidden_31 l2_msum_0 43478.260869565216
R_L2_m_32_0 hidden_32 l2_msum_0 241379.31034482759
R_L2_m_33_0 hidden_33 l2_msum_0 73684.210526315786
R_L2_m_34_0 hidden_34 l2_msum_0 1000000
R_L2_m_35_0 hidden_35 l2_msum_0 1000000
R_L2_m_36_0 hidden_36 l2_msum_0 112903.22580645159
R_L2_m_37_0 hidden_37 l2_msum_0 1000000
R_L2_m_38_0 hidden_38 l2_msum_0 1000000
R_L2_m_39_0 hidden_39 l2_msum_0 241379.31034482759
R_L2_m_40_0 hidden_40 l2_msum_0 54687.499999999993
R_L2_m_41_0 hidden_41 l2_msum_0 95890.410958904104
R_L2_m_42_0 hidden_42 l2_msum_0 11437.908496732027
R_L2_m_43_0 hidden_43 l2_msum_0 38251.366120218576
R_L2_m_44_0 hidden_44 l2_msum_0 1000000
R_L2_m_45_0 hidden_45 l2_msum_0 1000000
R_L2_m_46_0 hidden_46 l2_msum_0 1000000
R_L2_m_47_0 hidden_47 l2_msum_0 1000000
R_L2_m_48_0 hidden_48 l2_msum_0 29411.764705882353
R_L2_m_49_0 hidden_49 l2_msum_0 20114.942528735632
E_TIA_L2_m_0 l2_mout_0 0 0 l2_msum_0 100000000
R_FB_L2_m_0 l2_mout_0 l2_msum_0 1000
B_NEURON_L2_0 logit_0 0 V={0.01*((V(l2_mout_0)-V(l2_pout_0))/0.00031049501254658707+(-0.27133280038833618))}
R_L2_p_0_1 hidden_0 l2_psum_1 241379.31034482759
R_L2_p_1_1 hidden_1 l2_psum_1 1000000
R_L2_p_2_1 hidden_2 l2_psum_1 1000000
R_L2_p_3_1 hidden_3 l2_psum_1 241379.31034482759
R_L2_p_4_1 hidden_4 l2_psum_1 1000000
R_L2_p_5_1 hidden_5 l2_psum_1 388888.88888888888
R_L2_p_6_1 hidden_6 l2_psum_1 32407.407407407409
R_L2_p_7_1 hidden_7 l2_psum_1 1000000
R_L2_p_8_1 hidden_8 l2_psum_1 1000000
R_L2_p_9_1 hidden_9 l2_psum_1 32407.407407407409
R_L2_p_10_1 hidden_10 l2_psum_1 32407.407407407409
R_L2_p_11_1 hidden_11 l2_psum_1 34146.341463414632
R_L2_p_12_1 hidden_12 l2_psum_1 34146.341463414632
R_L2_p_13_1 hidden_13 l2_psum_1 1000000
R_L2_p_14_1 hidden_14 l2_psum_1 1000000
R_L2_p_15_1 hidden_15 l2_psum_1 54687.499999999993
R_L2_p_16_1 hidden_16 l2_psum_1 1000000
R_L2_p_17_1 hidden_17 l2_psum_1 17369.727047146403
R_L2_p_18_1 hidden_18 l2_psum_1 1000000
R_L2_p_19_1 hidden_19 l2_psum_1 1000000
R_L2_p_20_1 hidden_20 l2_psum_1 1000000
R_L2_p_21_1 hidden_21 l2_psum_1 16908.212560386473
R_L2_p_22_1 hidden_22 l2_psum_1 1000000
R_L2_p_23_1 hidden_23 l2_psum_1 38251.366120218576
R_L2_p_24_1 hidden_24 l2_psum_1 50359.712230215831
R_L2_p_25_1 hidden_25 l2_psum_1 66037.735849056597
R_L2_p_26_1 hidden_26 l2_psum_1 43478.260869565216
R_L2_p_27_1 hidden_27 l2_psum_1 1000000
R_L2_p_28_1 hidden_28 l2_psum_1 36082.474226804123
R_L2_p_29_1 hidden_29 l2_psum_1 112903.22580645159
R_L2_p_30_1 hidden_30 l2_psum_1 1000000
R_L2_p_31_1 hidden_31 l2_psum_1 1000000
R_L2_p_32_1 hidden_32 l2_psum_1 1000000
R_L2_p_33_1 hidden_33 l2_psum_1 1000000
R_L2_p_34_1 hidden_34 l2_psum_1 1000000
R_L2_p_35_1 hidden_35 l2_psum_1 19498.607242339833
R_L2_p_36_1 hidden_36 l2_psum_1 20114.942528735632
R_L2_p_37_1 hidden_37 l2_psum_1 32407.407407407409
R_L2_p_38_1 hidden_38 l2_psum_1 1000000
R_L2_p_39_1 hidden_39 l2_psum_1 73684.210526315786
R_L2_p_40_1 hidden_40 l2_psum_1 46666.666666666664
R_L2_p_41_1 hidden_41 l2_psum_1 175000.00000000003
R_L2_p_42_1 hidden_42 l2_psum_1 1000000
R_L2_p_43_1 hidden_43 l2_psum_1 59829.059829059821
R_L2_p_44_1 hidden_44 l2_psum_1 73684.210526315786
R_L2_p_45_1 hidden_45 l2_psum_1 1000000
R_L2_p_46_1 hidden_46 l2_psum_1 1000000
R_L2_p_47_1 hidden_47 l2_psum_1 1000000
R_L2_p_48_1 hidden_48 l2_psum_1 25830.258302583028
R_L2_p_49_1 hidden_49 l2_psum_1 1000000
E_TIA_L2_p_1 l2_pout_1 0 0 l2_psum_1 100000000
R_FB_L2_p_1 l2_pout_1 l2_psum_1 1000
R_L2_m_0_1 hidden_0 l2_msum_1 1000000
R_L2_m_1_1 hidden_1 l2_msum_1 29411.764705882353
R_L2_m_2_1 hidden_2 l2_msum_1 20114.942528735632
R_L2_m_3_1 hidden_3 l2_msum_1 1000000
R_L2_m_4_1 hidden_4 l2_msum_1 83333.333333333328
R_L2_m_5_1 hidden_5 l2_msum_1 1000000
R_L2_m_6_1 hidden_6 l2_msum_1 1000000
R_L2_m_7_1 hidden_7 l2_msum_1 54687.499999999993
R_L2_m_8_1 hidden_8 l2_msum_1 46666.666666666664
R_L2_m_9_1 hidden_9 l2_msum_1 1000000
R_L2_m_10_1 hidden_10 l2_msum_1 1000000
R_L2_m_11_1 hidden_11 l2_msum_1 1000000
R_L2_m_12_1 hidden_12 l2_msum_1 1000000
R_L2_m_13_1 hidden_13 l2_msum_1 23026.315789473687
R_L2_m_14_1 hidden_14 l2_msum_1 32407.407407407409
R_L2_m_15_1 hidden_15 l2_msum_1 1000000
R_L2_m_16_1 hidden_16 l2_msum_1 32407.407407407409
R_L2_m_17_1 hidden_17 l2_msum_1 1000000
R_L2_m_18_1 hidden_18 l2_msum_1 32407.407407407409
R_L2_m_19_1 hidden_19 l2_msum_1 95890.410958904104
R_L2_m_20_1 hidden_20 l2_msum_1 1000000
R_L2_m_21_1 hidden_21 l2_msum_1 1000000
R_L2_m_22_1 hidden_22 l2_msum_1 1000000
R_L2_m_23_1 hidden_23 l2_msum_1 1000000
R_L2_m_24_1 hidden_24 l2_msum_1 1000000
R_L2_m_25_1 hidden_25 l2_msum_1 1000000
R_L2_m_26_1 hidden_26 l2_msum_1 1000000
R_L2_m_27_1 hidden_27 l2_msum_1 54687.499999999993
R_L2_m_28_1 hidden_28 l2_msum_1 1000000
R_L2_m_29_1 hidden_29 l2_msum_1 1000000
R_L2_m_30_1 hidden_30 l2_msum_1 26923.076923076922
R_L2_m_31_1 hidden_31 l2_msum_1 388888.88888888888
R_L2_m_32_1 hidden_32 l2_msum_1 59829.059829059821
R_L2_m_33_1 hidden_33 l2_msum_1 32407.407407407409
R_L2_m_34_1 hidden_34 l2_msum_1 95890.410958904104
R_L2_m_35_1 hidden_35 l2_msum_1 1000000
R_L2_m_36_1 hidden_36 l2_msum_1 1000000
R_L2_m_37_1 hidden_37 l2_msum_1 1000000
R_L2_m_38_1 hidden_38 l2_msum_1 22222.222222222223
R_L2_m_39_1 hidden_39 l2_msum_1 1000000
R_L2_m_40_1 hidden_40 l2_msum_1 1000000
R_L2_m_41_1 hidden_41 l2_msum_1 1000000
R_L2_m_42_1 hidden_42 l2_msum_1 10324.48377581121
R_L2_m_43_1 hidden_43 l2_msum_1 1000000
R_L2_m_44_1 hidden_44 l2_msum_1 1000000
R_L2_m_45_1 hidden_45 l2_msum_1 18918.91891891892
R_L2_m_46_1 hidden_46 l2_msum_1 95890.410958904104
R_L2_m_47_1 hidden_47 l2_msum_1 50359.712230215831
R_L2_m_48_1 hidden_48 l2_msum_1 1000000
R_L2_m_49_1 hidden_49 l2_msum_1 30837.004405286345
E_TIA_L2_m_1 l2_mout_1 0 0 l2_msum_1 100000000
R_FB_L2_m_1 l2_mout_1 l2_msum_1 1000
B_NEURON_L2_1 logit_1 0 V={0.01*((V(l2_mout_1)-V(l2_pout_1))/0.00031049501254658707+(0.053374722599983215))}
R_L2_p_0_2 hidden_0 l2_psum_2 83333.333333333328
R_L2_p_1_2 hidden_1 l2_psum_2 1000000
R_L2_p_2_2 hidden_2 l2_psum_2 1000000
R_L2_p_3_2 hidden_3 l2_psum_2 1000000
R_L2_p_4_2 hidden_4 l2_psum_2 241379.31034482759
R_L2_p_5_2 hidden_5 l2_psum_2 1000000
R_L2_p_6_2 hidden_6 l2_psum_2 83333.333333333328
R_L2_p_7_2 hidden_7 l2_psum_2 54687.499999999993
R_L2_p_8_2 hidden_8 l2_psum_2 1000000
R_L2_p_9_2 hidden_9 l2_psum_2 17369.727047146403
R_L2_p_10_2 hidden_10 l2_psum_2 1000000
R_L2_p_11_2 hidden_11 l2_psum_2 54687.499999999993
R_L2_p_12_2 hidden_12 l2_psum_2 36082.474226804123
R_L2_p_13_2 hidden_13 l2_psum_2 36082.474226804123
R_L2_p_14_2 hidden_14 l2_psum_2 1000000
R_L2_p_15_2 hidden_15 l2_psum_2 1000000
R_L2_p_16_2 hidden_16 l2_psum_2 54687.499999999993
R_L2_p_17_2 hidden_17 l2_psum_2 1000000
R_L2_p_18_2 hidden_18 l2_psum_2 1000000
R_L2_p_19_2 hidden_19 l2_psum_2 36082.474226804123
R_L2_p_20_2 hidden_20 l2_psum_2 46666.666666666664
R_L2_p_21_2 hidden_21 l2_psum_2 388888.88888888888
R_L2_p_22_2 hidden_22 l2_psum_2 73684.210526315786
R_L2_p_23_2 hidden_23 l2_psum_2 112903.22580645159
R_L2_p_24_2 hidden_24 l2_psum_2 59829.059829059821
R_L2_p_25_2 hidden_25 l2_psum_2 1000000
R_L2_p_26_2 hidden_26 l2_psum_2 175000.00000000003
R_L2_p_27_2 hidden_27 l2_psum_2 112903.22580645159
R_L2_p_28_2 hidden_28 l2_psum_2 46666.666666666664
R_L2_p_29_2 hidden_29 l2_psum_2 50359.712230215831
R_L2_p_30_2 hidden_30 l2_psum_2 175000.00000000003
R_L2_p_31_2 hidden_31 l2_psum_2 38251.366120218576
R_L2_p_32_2 hidden_32 l2_psum_2 388888.88888888888
R_L2_p_33_2 hidden_33 l2_psum_2 1000000
R_L2_p_34_2 hidden_34 l2_psum_2 1000000
R_L2_p_35_2 hidden_35 l2_psum_2 1000000
R_L2_p_36_2 hidden_36 l2_psum_2 32407.407407407409
R_L2_p_37_2 hidden_37 l2_psum_2 1000000
R_L2_p_38_2 hidden_38 l2_psum_2 50359.712230215831
R_L2_p_39_2 hidden_39 l2_psum_2 73684.210526315786
R_L2_p_40_2 hidden_40 l2_psum_2 1000000
R_L2_p_41_2 hidden_41 l2_psum_2 1000000
R_L2_p_42_2 hidden_42 l2_psum_2 1000000
R_L2_p_43_2 hidden_43 l2_psum_2 54687.499999999993
R_L2_p_44_2 hidden_44 l2_psum_2 24822.695035460994
R_L2_p_45_2 hidden_45 l2_psum_2 1000000
R_L2_p_46_2 hidden_46 l2_psum_2 388888.88888888888
R_L2_p_47_2 hidden_47 l2_psum_2 1000000
R_L2_p_48_2 hidden_48 l2_psum_2 18918.91891891892
R_L2_p_49_2 hidden_49 l2_psum_2 46666.666666666664
E_TIA_L2_p_2 l2_pout_2 0 0 l2_psum_2 100000000
R_FB_L2_p_2 l2_pout_2 l2_psum_2 1000
R_L2_m_0_2 hidden_0 l2_msum_2 1000000
R_L2_m_1_2 hidden_1 l2_msum_2 34146.341463414632
R_L2_m_2_2 hidden_2 l2_msum_2 36082.474226804123
R_L2_m_3_2 hidden_3 l2_msum_2 38251.366120218576
R_L2_m_4_2 hidden_4 l2_msum_2 1000000
R_L2_m_5_2 hidden_5 l2_msum_2 388888.88888888888
R_L2_m_6_2 hidden_6 l2_msum_2 1000000
R_L2_m_7_2 hidden_7 l2_msum_2 1000000
R_L2_m_8_2 hidden_8 l2_msum_2 1000000
R_L2_m_9_2 hidden_9 l2_msum_2 1000000
R_L2_m_10_2 hidden_10 l2_msum_2 23026.315789473687
R_L2_m_11_2 hidden_11 l2_msum_2 1000000
R_L2_m_12_2 hidden_12 l2_msum_2 1000000
R_L2_m_13_2 hidden_13 l2_msum_2 1000000
R_L2_m_14_2 hidden_14 l2_msum_2 23026.315789473687
R_L2_m_15_2 hidden_15 l2_msum_2 388888.88888888888
R_L2_m_16_2 hidden_16 l2_msum_2 1000000
R_L2_m_17_2 hidden_17 l2_msum_2 34146.341463414632
R_L2_m_18_2 hidden_18 l2_msum_2 50359.712230215831
R_L2_m_19_2 hidden_19 l2_msum_2 1000000
R_L2_m_20_2 hidden_20 l2_msum_2 1000000
R_L2_m_21_2 hidden_21 l2_msum_2 1000000
R_L2_m_22_2 hidden_22 l2_msum_2 1000000
R_L2_m_23_2 hidden_23 l2_msum_2 1000000
R_L2_m_24_2 hidden_24 l2_msum_2 1000000
R_L2_m_25_2 hidden_25 l2_msum_2 175000.00000000003
R_L2_m_26_2 hidden_26 l2_msum_2 1000000
R_L2_m_27_2 hidden_27 l2_msum_2 1000000
R_L2_m_28_2 hidden_28 l2_msum_2 1000000
R_L2_m_29_2 hidden_29 l2_msum_2 1000000
R_L2_m_30_2 hidden_30 l2_msum_2 1000000
R_L2_m_31_2 hidden_31 l2_msum_2 1000000
R_L2_m_32_2 hidden_32 l2_msum_2 1000000
R_L2_m_33_2 hidden_33 l2_msum_2 54687.499999999993
R_L2_m_34_2 hidden_34 l2_msum_2 13358.778625954199
R_L2_m_35_2 hidden_35 l2_msum_2 18918.91891891892
R_L2_m_36_2 hidden_36 l2_msum_2 1000000
R_L2_m_37_2 hidden_37 l2_msum_2 23026.315789473687
R_L2_m_38_2 hidden_38 l2_msum_2 1000000
R_L2_m_39_2 hidden_39 l2_msum_2 1000000
R_L2_m_40_2 hidden_40 l2_msum_2 17857.142857142859
R_L2_m_41_2 hidden_41 l2_msum_2 15659.955257270693
R_L2_m_42_2 hidden_42 l2_msum_2 17857.142857142859
R_L2_m_43_2 hidden_43 l2_msum_2 1000000
R_L2_m_44_2 hidden_44 l2_msum_2 1000000
R_L2_m_45_2 hidden_45 l2_msum_2 112903.22580645159
R_L2_m_46_2 hidden_46 l2_msum_2 1000000
R_L2_m_47_2 hidden_47 l2_msum_2 1000000
R_L2_m_48_2 hidden_48 l2_msum_2 1000000
R_L2_m_49_2 hidden_49 l2_msum_2 1000000
E_TIA_L2_m_2 l2_mout_2 0 0 l2_msum_2 100000000
R_FB_L2_m_2 l2_mout_2 l2_msum_2 1000
B_NEURON_L2_2 logit_2 0 V={0.01*((V(l2_mout_2)-V(l2_pout_2))/0.00031049501254658707+(0.16175372898578644))}
R_L2_p_0_3 hidden_0 l2_psum_3 50359.712230215831
R_L2_p_1_3 hidden_1 l2_psum_3 1000000
R_L2_p_2_3 hidden_2 l2_psum_3 1000000
R_L2_p_3_3 hidden_3 l2_psum_3 50359.712230215831
R_L2_p_4_3 hidden_4 l2_psum_3 38251.366120218576
R_L2_p_5_3 hidden_5 l2_psum_3 1000000
R_L2_p_6_3 hidden_6 l2_psum_3 1000000
R_L2_p_7_3 hidden_7 l2_psum_3 54687.499999999993
R_L2_p_8_3 hidden_8 l2_psum_3 66037.735849056597
R_L2_p_9_3 hidden_9 l2_psum_3 1000000
R_L2_p_10_3 hidden_10 l2_psum_3 1000000
R_L2_p_11_3 hidden_11 l2_psum_3 1000000
R_L2_p_12_3 hidden_12 l2_psum_3 388888.88888888888
R_L2_p_13_3 hidden_13 l2_psum_3 83333.333333333328
R_L2_p_14_3 hidden_14 l2_psum_3 29411.764705882353
R_L2_p_15_3 hidden_15 l2_psum_3 112903.22580645159
R_L2_p_16_3 hidden_16 l2_psum_3 1000000
R_L2_p_17_3 hidden_17 l2_psum_3 73684.210526315786
R_L2_p_18_3 hidden_18 l2_psum_3 1000000
R_L2_p_19_3 hidden_19 l2_psum_3 388888.88888888888
R_L2_p_20_3 hidden_20 l2_psum_3 66037.735849056597
R_L2_p_21_3 hidden_21 l2_psum_3 95890.410958904104
R_L2_p_22_3 hidden_22 l2_psum_3 1000000
R_L2_p_23_3 hidden_23 l2_psum_3 1000000
R_L2_p_24_3 hidden_24 l2_psum_3 54687.499999999993
R_L2_p_25_3 hidden_25 l2_psum_3 83333.333333333328
R_L2_p_26_3 hidden_26 l2_psum_3 18372.70341207349
R_L2_p_27_3 hidden_27 l2_psum_3 1000000
R_L2_p_28_3 hidden_28 l2_psum_3 1000000
R_L2_p_29_3 hidden_29 l2_psum_3 59829.059829059821
R_L2_p_30_3 hidden_30 l2_psum_3 1000000
R_L2_p_31_3 hidden_31 l2_psum_3 50359.712230215831
R_L2_p_32_3 hidden_32 l2_psum_3 1000000
R_L2_p_33_3 hidden_33 l2_psum_3 59829.059829059821
R_L2_p_34_3 hidden_34 l2_psum_3 1000000
R_L2_p_35_3 hidden_35 l2_psum_3 1000000
R_L2_p_36_3 hidden_36 l2_psum_3 1000000
R_L2_p_37_3 hidden_37 l2_psum_3 1000000
R_L2_p_38_3 hidden_38 l2_psum_3 83333.333333333328
R_L2_p_39_3 hidden_39 l2_psum_3 1000000
R_L2_p_40_3 hidden_40 l2_psum_3 32407.407407407409
R_L2_p_41_3 hidden_41 l2_psum_3 34146.341463414632
R_L2_p_42_3 hidden_42 l2_psum_3 28112.449799196787
R_L2_p_43_3 hidden_43 l2_psum_3 46666.666666666664
R_L2_p_44_3 hidden_44 l2_psum_3 1000000
R_L2_p_45_3 hidden_45 l2_psum_3 66037.735849056597
R_L2_p_46_3 hidden_46 l2_psum_3 1000000
R_L2_p_47_3 hidden_47 l2_psum_3 1000000
R_L2_p_48_3 hidden_48 l2_psum_3 1000000
R_L2_p_49_3 hidden_49 l2_psum_3 29411.764705882353
E_TIA_L2_p_3 l2_pout_3 0 0 l2_psum_3 100000000
R_FB_L2_p_3 l2_pout_3 l2_psum_3 1000
R_L2_m_0_3 hidden_0 l2_msum_3 1000000
R_L2_m_1_3 hidden_1 l2_msum_3 40697.674418604649
R_L2_m_2_3 hidden_2 l2_msum_3 83333.333333333328
R_L2_m_3_3 hidden_3 l2_msum_3 1000000
R_L2_m_4_3 hidden_4 l2_msum_3 1000000
R_L2_m_5_3 hidden_5 l2_msum_3 83333.333333333328
R_L2_m_6_3 hidden_6 l2_msum_3 38251.366120218576
R_L2_m_7_3 hidden_7 l2_msum_3 1000000
R_L2_m_8_3 hidden_8 l2_msum_3 1000000
R_L2_m_9_3 hidden_9 l2_msum_3 21472.39263803681
R_L2_m_10_3 hidden_10 l2_msum_3 16055.045871559634
R_L2_m_11_3 hidden_11 l2_msum_3 43478.260869565216
R_L2_m_12_3 hidden_12 l2_msum_3 1000000
R_L2_m_13_3 hidden_13 l2_msum_3 1000000
R_L2_m_14_3 hidden_14 l2_msum_3 1000000
R_L2_m_15_3 hidden_15 l2_msum_3 1000000
R_L2_m_16_3 hidden_16 l2_msum_3 50359.712230215831
R_L2_m_17_3 hidden_17 l2_msum_3 1000000
R_L2_m_18_3 hidden_18 l2_msum_3 112903.22580645159
R_L2_m_19_3 hidden_19 l2_msum_3 1000000
R_L2_m_20_3 hidden_20 l2_msum_3 1000000
R_L2_m_21_3 hidden_21 l2_msum_3 1000000
R_L2_m_22_3 hidden_22 l2_msum_3 26923.076923076922
R_L2_m_23_3 hidden_23 l2_msum_3 40697.674418604649
R_L2_m_24_3 hidden_24 l2_msum_3 1000000
R_L2_m_25_3 hidden_25 l2_msum_3 1000000
R_L2_m_26_3 hidden_26 l2_msum_3 1000000
R_L2_m_27_3 hidden_27 l2_msum_3 112903.22580645159
R_L2_m_28_3 hidden_28 l2_msum_3 36082.474226804123
R_L2_m_29_3 hidden_29 l2_msum_3 1000000
R_L2_m_30_3 hidden_30 l2_msum_3 32407.407407407409
R_L2_m_31_3 hidden_31 l2_msum_3 1000000
R_L2_m_32_3 hidden_32 l2_msum_3 241379.31034482759
R_L2_m_33_3 hidden_33 l2_msum_3 1000000
R_L2_m_34_3 hidden_34 l2_msum_3 34146.341463414632
R_L2_m_35_3 hidden_35 l2_msum_3 14583.333333333334
R_L2_m_36_3 hidden_36 l2_msum_3 112903.22580645159
R_L2_m_37_3 hidden_37 l2_msum_3 83333.333333333328
R_L2_m_38_3 hidden_38 l2_msum_3 1000000
R_L2_m_39_3 hidden_39 l2_msum_3 18918.91891891892
R_L2_m_40_3 hidden_40 l2_msum_3 1000000
R_L2_m_41_3 hidden_41 l2_msum_3 1000000
R_L2_m_42_3 hidden_42 l2_msum_3 1000000
R_L2_m_43_3 hidden_43 l2_msum_3 1000000
R_L2_m_44_3 hidden_44 l2_msum_3 34146.341463414632
R_L2_m_45_3 hidden_45 l2_msum_3 1000000
R_L2_m_46_3 hidden_46 l2_msum_3 95890.410958904104
R_L2_m_47_3 hidden_47 l2_msum_3 36082.474226804123
R_L2_m_48_3 hidden_48 l2_msum_3 137254.90196078431
R_L2_m_49_3 hidden_49 l2_msum_3 1000000
E_TIA_L2_m_3 l2_mout_3 0 0 l2_msum_3 100000000
R_FB_L2_m_3 l2_mout_3 l2_msum_3 1000
B_NEURON_L2_3 logit_3 0 V={0.01*((V(l2_mout_3)-V(l2_pout_3))/0.00031049501254658707+(-0.13433626294136047))}
R_L2_p_0_4 hidden_0 l2_psum_4 54687.499999999993
R_L2_p_1_4 hidden_1 l2_psum_4 46666.666666666664
R_L2_p_2_4 hidden_2 l2_psum_4 59829.059829059821
R_L2_p_3_4 hidden_3 l2_psum_4 1000000
R_L2_p_4_4 hidden_4 l2_psum_4 1000000
R_L2_p_5_4 hidden_5 l2_psum_4 1000000
R_L2_p_6_4 hidden_6 l2_psum_4 1000000
R_L2_p_7_4 hidden_7 l2_psum_4 1000000
R_L2_p_8_4 hidden_8 l2_psum_4 112903.22580645159
R_L2_p_9_4 hidden_9 l2_psum_4 137254.90196078431
R_L2_p_10_4 hidden_10 l2_psum_4 26923.076923076922
R_L2_p_11_4 hidden_11 l2_psum_4 1000000
R_L2_p_12_4 hidden_12 l2_psum_4 1000000
R_L2_p_13_4 hidden_13 l2_psum_4 1000000
R_L2_p_14_4 hidden_14 l2_psum_4 50359.712230215831
R_L2_p_15_4 hidden_15 l2_psum_4 1000000
R_L2_p_16_4 hidden_16 l2_psum_4 112903.22580645159
R_L2_p_17_4 hidden_17 l2_psum_4 73684.210526315786
R_L2_p_18_4 hidden_18 l2_psum_4 112903.22580645159
R_L2_p_19_4 hidden_19 l2_psum_4 1000000
R_L2_p_20_4 hidden_20 l2_psum_4 1000000
R_L2_p_21_4 hidden_21 l2_psum_4 23026.315789473687
R_L2_p_22_4 hidden_22 l2_psum_4 59829.059829059821
R_L2_p_23_4 hidden_23 l2_psum_4 1000000
R_L2_p_24_4 hidden_24 l2_psum_4 34146.341463414632
R_L2_p_25_4 hidden_25 l2_psum_4 137254.90196078431
R_L2_p_26_4 hidden_26 l2_psum_4 1000000
R_L2_p_27_4 hidden_27 l2_psum_4 1000000
R_L2_p_28_4 hidden_28 l2_psum_4 40697.674418604649
R_L2_p_29_4 hidden_29 l2_psum_4 1000000
R_L2_p_30_4 hidden_30 l2_psum_4 36082.474226804123
R_L2_p_31_4 hidden_31 l2_psum_4 1000000
R_L2_p_32_4 hidden_32 l2_psum_4 73684.210526315786
R_L2_p_33_4 hidden_33 l2_psum_4 175000.00000000003
R_L2_p_34_4 hidden_34 l2_psum_4 46666.666666666664
R_L2_p_35_4 hidden_35 l2_psum_4 112903.22580645159
R_L2_p_36_4 hidden_36 l2_psum_4 1000000
R_L2_p_37_4 hidden_37 l2_psum_4 1000000
R_L2_p_38_4 hidden_38 l2_psum_4 1000000
R_L2_p_39_4 hidden_39 l2_psum_4 1000000
R_L2_p_40_4 hidden_40 l2_psum_4 30837.004405286345
R_L2_p_41_4 hidden_41 l2_psum_4 1000000
R_L2_p_42_4 hidden_42 l2_psum_4 241379.31034482759
R_L2_p_43_4 hidden_43 l2_psum_4 21472.39263803681
R_L2_p_44_4 hidden_44 l2_psum_4 43478.260869565216
R_L2_p_45_4 hidden_45 l2_psum_4 1000000
R_L2_p_46_4 hidden_46 l2_psum_4 1000000
R_L2_p_47_4 hidden_47 l2_psum_4 73684.210526315786
R_L2_p_48_4 hidden_48 l2_psum_4 1000000
R_L2_p_49_4 hidden_49 l2_psum_4 1000000
E_TIA_L2_p_4 l2_pout_4 0 0 l2_psum_4 100000000
R_FB_L2_p_4 l2_pout_4 l2_psum_4 1000
R_L2_m_0_4 hidden_0 l2_msum_4 1000000
R_L2_m_1_4 hidden_1 l2_msum_4 1000000
R_L2_m_2_4 hidden_2 l2_msum_4 1000000
R_L2_m_3_4 hidden_3 l2_msum_4 29411.764705882353
R_L2_m_4_4 hidden_4 l2_msum_4 73684.210526315786
R_L2_m_5_4 hidden_5 l2_msum_4 137254.90196078431
R_L2_m_6_4 hidden_6 l2_msum_4 73684.210526315786
R_L2_m_7_4 hidden_7 l2_msum_4 40697.674418604649
R_L2_m_8_4 hidden_8 l2_msum_4 1000000
R_L2_m_9_4 hidden_9 l2_msum_4 1000000
R_L2_m_10_4 hidden_10 l2_msum_4 1000000
R_L2_m_11_4 hidden_11 l2_msum_4 1000000
R_L2_m_12_4 hidden_12 l2_msum_4 20771.51335311573
R_L2_m_13_4 hidden_13 l2_msum_4 95890.410958904104
R_L2_m_14_4 hidden_14 l2_msum_4 1000000
R_L2_m_15_4 hidden_15 l2_msum_4 34146.341463414632
R_L2_m_16_4 hidden_16 l2_msum_4 1000000
R_L2_m_17_4 hidden_17 l2_msum_4 1000000
R_L2_m_18_4 hidden_18 l2_msum_4 1000000
R_L2_m_19_4 hidden_19 l2_msum_4 12567.324955116697
R_L2_m_20_4 hidden_20 l2_msum_4 20771.51335311573
R_L2_m_21_4 hidden_21 l2_msum_4 1000000
R_L2_m_22_4 hidden_22 l2_msum_4 1000000
R_L2_m_23_4 hidden_23 l2_msum_4 18372.70341207349
R_L2_m_24_4 hidden_24 l2_msum_4 1000000
R_L2_m_25_4 hidden_25 l2_msum_4 1000000
R_L2_m_26_4 hidden_26 l2_msum_4 16908.212560386473
R_L2_m_27_4 hidden_27 l2_msum_4 73684.210526315786
R_L2_m_28_4 hidden_28 l2_msum_4 1000000
R_L2_m_29_4 hidden_29 l2_msum_4 20771.51335311573
R_L2_m_30_4 hidden_30 l2_msum_4 1000000
R_L2_m_31_4 hidden_31 l2_msum_4 73684.210526315786
R_L2_m_32_4 hidden_32 l2_msum_4 1000000
R_L2_m_33_4 hidden_33 l2_msum_4 1000000
R_L2_m_34_4 hidden_34 l2_msum_4 1000000
R_L2_m_35_4 hidden_35 l2_msum_4 1000000
R_L2_m_36_4 hidden_36 l2_msum_4 175000.00000000003
R_L2_m_37_4 hidden_37 l2_msum_4 24822.695035460994
R_L2_m_38_4 hidden_38 l2_msum_4 388888.88888888888
R_L2_m_39_4 hidden_39 l2_msum_4 388888.88888888888
R_L2_m_40_4 hidden_40 l2_msum_4 1000000
R_L2_m_41_4 hidden_41 l2_msum_4 30837.004405286345
R_L2_m_42_4 hidden_42 l2_msum_4 1000000
R_L2_m_43_4 hidden_43 l2_msum_4 1000000
R_L2_m_44_4 hidden_44 l2_msum_4 1000000
R_L2_m_45_4 hidden_45 l2_msum_4 66037.735849056597
R_L2_m_46_4 hidden_46 l2_msum_4 66037.735849056597
R_L2_m_47_4 hidden_47 l2_msum_4 1000000
R_L2_m_48_4 hidden_48 l2_msum_4 175000.00000000003
R_L2_m_49_4 hidden_49 l2_msum_4 16908.212560386473
E_TIA_L2_m_4 l2_mout_4 0 0 l2_msum_4 100000000
R_FB_L2_m_4 l2_mout_4 l2_msum_4 1000
B_NEURON_L2_4 logit_4 0 V={0.01*((V(l2_mout_4)-V(l2_pout_4))/0.00031049501254658707+(-0.025701504200696945))}
R_L2_p_0_5 hidden_0 l2_psum_5 1000000
R_L2_p_1_5 hidden_1 l2_psum_5 83333.333333333328
R_L2_p_2_5 hidden_2 l2_psum_5 25830.258302583028
R_L2_p_3_5 hidden_3 l2_psum_5 38251.366120218576
R_L2_p_4_5 hidden_4 l2_psum_5 32407.407407407409
R_L2_p_5_5 hidden_5 l2_psum_5 1000000
R_L2_p_6_5 hidden_6 l2_psum_5 17857.142857142859
R_L2_p_7_5 hidden_7 l2_psum_5 1000000
R_L2_p_8_5 hidden_8 l2_psum_5 1000000
R_L2_p_9_5 hidden_9 l2_psum_5 38251.366120218576
R_L2_p_10_5 hidden_10 l2_psum_5 1000000
R_L2_p_11_5 hidden_11 l2_psum_5 1000000
R_L2_p_12_5 hidden_12 l2_psum_5 95890.410958904104
R_L2_p_13_5 hidden_13 l2_psum_5 1000000
R_L2_p_14_5 hidden_14 l2_psum_5 59829.059829059821
R_L2_p_15_5 hidden_15 l2_psum_5 1000000
R_L2_p_16_5 hidden_16 l2_psum_5 1000000
R_L2_p_17_5 hidden_17 l2_psum_5 1000000
R_L2_p_18_5 hidden_18 l2_psum_5 1000000
R_L2_p_19_5 hidden_19 l2_psum_5 83333.333333333328
R_L2_p_20_5 hidden_20 l2_psum_5 29411.764705882353
R_L2_p_21_5 hidden_21 l2_psum_5 175000.00000000003
R_L2_p_22_5 hidden_22 l2_psum_5 137254.90196078431
R_L2_p_23_5 hidden_23 l2_psum_5 83333.333333333328
R_L2_p_24_5 hidden_24 l2_psum_5 1000000
R_L2_p_25_5 hidden_25 l2_psum_5 1000000
R_L2_p_26_5 hidden_26 l2_psum_5 1000000
R_L2_p_27_5 hidden_27 l2_psum_5 1000000
R_L2_p_28_5 hidden_28 l2_psum_5 1000000
R_L2_p_29_5 hidden_29 l2_psum_5 1000000
R_L2_p_30_5 hidden_30 l2_psum_5 388888.88888888888
R_L2_p_31_5 hidden_31 l2_psum_5 43478.260869565216
R_L2_p_32_5 hidden_32 l2_psum_5 241379.31034482759
R_L2_p_33_5 hidden_33 l2_psum_5 1000000
R_L2_p_34_5 hidden_34 l2_psum_5 29411.764705882353
R_L2_p_35_5 hidden_35 l2_psum_5 1000000
R_L2_p_36_5 hidden_36 l2_psum_5 1000000
R_L2_p_37_5 hidden_37 l2_psum_5 30837.004405286345
R_L2_p_38_5 hidden_38 l2_psum_5 1000000
R_L2_p_39_5 hidden_39 l2_psum_5 66037.735849056597
R_L2_p_40_5 hidden_40 l2_psum_5 95890.410958904104
R_L2_p_41_5 hidden_41 l2_psum_5 25830.258302583028
R_L2_p_42_5 hidden_42 l2_psum_5 16055.045871559634
R_L2_p_43_5 hidden_43 l2_psum_5 1000000
R_L2_p_44_5 hidden_44 l2_psum_5 46666.666666666664
R_L2_p_45_5 hidden_45 l2_psum_5 1000000
R_L2_p_46_5 hidden_46 l2_psum_5 1000000
R_L2_p_47_5 hidden_47 l2_psum_5 1000000
R_L2_p_48_5 hidden_48 l2_psum_5 112903.22580645159
R_L2_p_49_5 hidden_49 l2_psum_5 40697.674418604649
E_TIA_L2_p_5 l2_pout_5 0 0 l2_psum_5 100000000
R_FB_L2_p_5 l2_pout_5 l2_psum_5 1000
R_L2_m_0_5 hidden_0 l2_msum_5 11235.955056179775
R_L2_m_1_5 hidden_1 l2_msum_5 1000000
R_L2_m_2_5 hidden_2 l2_msum_5 1000000
R_L2_m_3_5 hidden_3 l2_msum_5 1000000
R_L2_m_4_5 hidden_4 l2_msum_5 1000000
R_L2_m_5_5 hidden_5 l2_msum_5 13358.778625954199
R_L2_m_6_5 hidden_6 l2_msum_5 1000000
R_L2_m_7_5 hidden_7 l2_msum_5 388888.88888888888
R_L2_m_8_5 hidden_8 l2_msum_5 241379.31034482759
R_L2_m_9_5 hidden_9 l2_msum_5 1000000
R_L2_m_10_5 hidden_10 l2_msum_5 73684.210526315786
R_L2_m_11_5 hidden_11 l2_msum_5 14925.373134328358
R_L2_m_12_5 hidden_12 l2_msum_5 1000000
R_L2_m_13_5 hidden_13 l2_msum_5 66037.735849056597
R_L2_m_14_5 hidden_14 l2_msum_5 1000000
R_L2_m_15_5 hidden_15 l2_msum_5 50359.712230215831
R_L2_m_16_5 hidden_16 l2_msum_5 54687.499999999993
R_L2_m_17_5 hidden_17 l2_msum_5 38251.366120218576
R_L2_m_18_5 hidden_18 l2_msum_5 388888.88888888888
R_L2_m_19_5 hidden_19 l2_msum_5 1000000
R_L2_m_20_5 hidden_20 l2_msum_5 1000000
R_L2_m_21_5 hidden_21 l2_msum_5 1000000
R_L2_m_22_5 hidden_22 l2_msum_5 1000000
R_L2_m_23_5 hidden_23 l2_msum_5 1000000
R_L2_m_24_5 hidden_24 l2_msum_5 29411.764705882353
R_L2_m_25_5 hidden_25 l2_msum_5 15659.955257270693
R_L2_m_26_5 hidden_26 l2_msum_5 40697.674418604649
R_L2_m_27_5 hidden_27 l2_msum_5 32407.407407407409
R_L2_m_28_5 hidden_28 l2_msum_5 28112.449799196787
R_L2_m_29_5 hidden_29 l2_msum_5 112903.22580645159
R_L2_m_30_5 hidden_30 l2_msum_5 1000000
R_L2_m_31_5 hidden_31 l2_msum_5 1000000
R_L2_m_32_5 hidden_32 l2_msum_5 1000000
R_L2_m_33_5 hidden_33 l2_msum_5 83333.333333333328
R_L2_m_34_5 hidden_34 l2_msum_5 1000000
R_L2_m_35_5 hidden_35 l2_msum_5 112903.22580645159
R_L2_m_36_5 hidden_36 l2_msum_5 11864.406779661016
R_L2_m_37_5 hidden_37 l2_msum_5 1000000
R_L2_m_38_5 hidden_38 l2_msum_5 34146.341463414632
R_L2_m_39_5 hidden_39 l2_msum_5 1000000
R_L2_m_40_5 hidden_40 l2_msum_5 1000000
R_L2_m_41_5 hidden_41 l2_msum_5 1000000
R_L2_m_42_5 hidden_42 l2_msum_5 1000000
R_L2_m_43_5 hidden_43 l2_msum_5 54687.499999999993
R_L2_m_44_5 hidden_44 l2_msum_5 1000000
R_L2_m_45_5 hidden_45 l2_msum_5 112903.22580645159
R_L2_m_46_5 hidden_46 l2_msum_5 43478.260869565216
R_L2_m_47_5 hidden_47 l2_msum_5 388888.88888888888
R_L2_m_48_5 hidden_48 l2_msum_5 1000000
R_L2_m_49_5 hidden_49 l2_msum_5 1000000
E_TIA_L2_m_5 l2_mout_5 0 0 l2_msum_5 100000000
R_FB_L2_m_5 l2_mout_5 l2_msum_5 1000
B_NEURON_L2_5 logit_5 0 V={0.01*((V(l2_mout_5)-V(l2_pout_5))/0.00031049501254658707+(0.086866706609725952))}
R_L2_p_0_6 hidden_0 l2_psum_6 1000000
R_L2_p_1_6 hidden_1 l2_psum_6 59829.059829059821
R_L2_p_2_6 hidden_2 l2_psum_6 30837.004405286345
R_L2_p_3_6 hidden_3 l2_psum_6 1000000
R_L2_p_4_6 hidden_4 l2_psum_6 1000000
R_L2_p_5_6 hidden_5 l2_psum_6 1000000
R_L2_p_6_6 hidden_6 l2_psum_6 1000000
R_L2_p_7_6 hidden_7 l2_psum_6 50359.712230215831
R_L2_p_8_6 hidden_8 l2_psum_6 1000000
R_L2_p_9_6 hidden_9 l2_psum_6 1000000
R_L2_p_10_6 hidden_10 l2_psum_6 46666.666666666664
R_L2_p_11_6 hidden_11 l2_psum_6 1000000
R_L2_p_12_6 hidden_12 l2_psum_6 66037.735849056597
R_L2_p_13_6 hidden_13 l2_psum_6 54687.499999999993
R_L2_p_14_6 hidden_14 l2_psum_6 1000000
R_L2_p_15_6 hidden_15 l2_psum_6 95890.410958904104
R_L2_p_16_6 hidden_16 l2_psum_6 1000000
R_L2_p_17_6 hidden_17 l2_psum_6 26923.076923076922
R_L2_p_18_6 hidden_18 l2_psum_6 1000000
R_L2_p_19_6 hidden_19 l2_psum_6 1000000
R_L2_p_20_6 hidden_20 l2_psum_6 137254.90196078431
R_L2_p_21_6 hidden_21 l2_psum_6 1000000
R_L2_p_22_6 hidden_22 l2_psum_6 73684.210526315786
R_L2_p_23_6 hidden_23 l2_psum_6 1000000
R_L2_p_24_6 hidden_24 l2_psum_6 1000000
R_L2_p_25_6 hidden_25 l2_psum_6 1000000
R_L2_p_26_6 hidden_26 l2_psum_6 1000000
R_L2_p_27_6 hidden_27 l2_psum_6 175000.00000000003
R_L2_p_28_6 hidden_28 l2_psum_6 38251.366120218576
R_L2_p_29_6 hidden_29 l2_psum_6 1000000
R_L2_p_30_6 hidden_30 l2_psum_6 1000000
R_L2_p_31_6 hidden_31 l2_psum_6 1000000
R_L2_p_32_6 hidden_32 l2_psum_6 46666.666666666664
R_L2_p_33_6 hidden_33 l2_psum_6 1000000
R_L2_p_34_6 hidden_34 l2_psum_6 46666.666666666664
R_L2_p_35_6 hidden_35 l2_psum_6 20771.51335311573
R_L2_p_36_6 hidden_36 l2_psum_6 1000000
R_L2_p_37_6 hidden_37 l2_psum_6 83333.333333333328
R_L2_p_38_6 hidden_38 l2_psum_6 21472.39263803681
R_L2_p_39_6 hidden_39 l2_psum_6 40697.674418604649
R_L2_p_40_6 hidden_40 l2_psum_6 1000000
R_L2_p_41_6 hidden_41 l2_psum_6 1000000
R_L2_p_42_6 hidden_42 l2_psum_6 1000000
R_L2_p_43_6 hidden_43 l2_psum_6 1000000
R_L2_p_44_6 hidden_44 l2_psum_6 83333.333333333328
R_L2_p_45_6 hidden_45 l2_psum_6 1000000
R_L2_p_46_6 hidden_46 l2_psum_6 83333.333333333328
R_L2_p_47_6 hidden_47 l2_psum_6 137254.90196078431
R_L2_p_48_6 hidden_48 l2_psum_6 1000000
R_L2_p_49_6 hidden_49 l2_psum_6 1000000
E_TIA_L2_p_6 l2_pout_6 0 0 l2_psum_6 100000000
R_FB_L2_p_6 l2_pout_6 l2_psum_6 1000
R_L2_m_0_6 hidden_0 l2_msum_6 28112.449799196787
R_L2_m_1_6 hidden_1 l2_msum_6 1000000
R_L2_m_2_6 hidden_2 l2_msum_6 1000000
R_L2_m_3_6 hidden_3 l2_msum_6 1000000
R_L2_m_4_6 hidden_4 l2_msum_6 18918.91891891892
R_L2_m_5_6 hidden_5 l2_msum_6 59829.059829059821
R_L2_m_6_6 hidden_6 l2_msum_6 14256.619144602852
R_L2_m_7_6 hidden_7 l2_msum_6 1000000
R_L2_m_8_6 hidden_8 l2_msum_6 241379.31034482759
R_L2_m_9_6 hidden_9 l2_msum_6 21472.39263803681
R_L2_m_10_6 hidden_10 l2_msum_6 1000000
R_L2_m_11_6 hidden_11 l2_msum_6 83333.333333333328
R_L2_m_12_6 hidden_12 l2_msum_6 1000000
R_L2_m_13_6 hidden_13 l2_msum_6 1000000
R_L2_m_14_6 hidden_14 l2_msum_6 23890.784982935158
R_L2_m_15_6 hidden_15 l2_msum_6 1000000
R_L2_m_16_6 hidden_16 l2_msum_6 40697.674418604649
R_L2_m_17_6 hidden_17 l2_msum_6 1000000
R_L2_m_18_6 hidden_18 l2_msum_6 1000000
R_L2_m_19_6 hidden_19 l2_msum_6 175000.00000000003
R_L2_m_20_6 hidden_20 l2_msum_6 1000000
R_L2_m_21_6 hidden_21 l2_msum_6 28112.449799196787
R_L2_m_22_6 hidden_22 l2_msum_6 1000000
R_L2_m_23_6 hidden_23 l2_msum_6 28112.449799196787
R_L2_m_24_6 hidden_24 l2_msum_6 66037.735849056597
R_L2_m_25_6 hidden_25 l2_msum_6 18918.91891891892
R_L2_m_26_6 hidden_26 l2_msum_6 66037.735849056597
R_L2_m_27_6 hidden_27 l2_msum_6 1000000
R_L2_m_28_6 hidden_28 l2_msum_6 1000000
R_L2_m_29_6 hidden_29 l2_msum_6 59829.059829059821
R_L2_m_30_6 hidden_30 l2_msum_6 28112.449799196787
R_L2_m_31_6 hidden_31 l2_msum_6 46666.666666666664
R_L2_m_32_6 hidden_32 l2_msum_6 1000000
R_L2_m_33_6 hidden_33 l2_msum_6 23026.315789473687
R_L2_m_34_6 hidden_34 l2_msum_6 1000000
R_L2_m_35_6 hidden_35 l2_msum_6 1000000
R_L2_m_36_6 hidden_36 l2_msum_6 24822.695035460994
R_L2_m_37_6 hidden_37 l2_msum_6 1000000
R_L2_m_38_6 hidden_38 l2_msum_6 1000000
R_L2_m_39_6 hidden_39 l2_msum_6 1000000
R_L2_m_40_6 hidden_40 l2_msum_6 112903.22580645159
R_L2_m_41_6 hidden_41 l2_msum_6 38251.366120218576
R_L2_m_42_6 hidden_42 l2_msum_6 112903.22580645159
R_L2_m_43_6 hidden_43 l2_msum_6 54687.499999999993
R_L2_m_44_6 hidden_44 l2_msum_6 1000000
R_L2_m_45_6 hidden_45 l2_msum_6 112903.22580645159
R_L2_m_46_6 hidden_46 l2_msum_6 1000000
R_L2_m_47_6 hidden_47 l2_msum_6 1000000
R_L2_m_48_6 hidden_48 l2_msum_6 36082.474226804123
R_L2_m_49_6 hidden_49 l2_msum_6 38251.366120218576
E_TIA_L2_m_6 l2_mout_6 0 0 l2_msum_6 100000000
R_FB_L2_m_6 l2_mout_6 l2_msum_6 1000
B_NEURON_L2_6 logit_6 0 V={0.01*((V(l2_mout_6)-V(l2_pout_6))/0.00031049501254658707+(-0.13398492336273193))}
R_L2_p_0_7 hidden_0 l2_psum_7 1000000
R_L2_p_1_7 hidden_1 l2_psum_7 1000000
R_L2_p_2_7 hidden_2 l2_psum_7 241379.31034482759
R_L2_p_3_7 hidden_3 l2_psum_7 1000000
R_L2_p_4_7 hidden_4 l2_psum_7 241379.31034482759
R_L2_p_5_7 hidden_5 l2_psum_7 388888.88888888888
R_L2_p_6_7 hidden_6 l2_psum_7 46666.666666666664
R_L2_p_7_7 hidden_7 l2_psum_7 1000000
R_L2_p_8_7 hidden_8 l2_psum_7 1000000
R_L2_p_9_7 hidden_9 l2_psum_7 38251.366120218576
R_L2_p_10_7 hidden_10 l2_psum_7 1000000
R_L2_p_11_7 hidden_11 l2_psum_7 22222.222222222223
R_L2_p_12_7 hidden_12 l2_psum_7 1000000
R_L2_p_13_7 hidden_13 l2_psum_7 175000.00000000003
R_L2_p_14_7 hidden_14 l2_psum_7 1000000
R_L2_p_15_7 hidden_15 l2_psum_7 1000000
R_L2_p_16_7 hidden_16 l2_psum_7 1000000
R_L2_p_17_7 hidden_17 l2_psum_7 1000000
R_L2_p_18_7 hidden_18 l2_psum_7 1000000
R_L2_p_19_7 hidden_19 l2_psum_7 54687.499999999993
R_L2_p_20_7 hidden_20 l2_psum_7 19498.607242339833
R_L2_p_21_7 hidden_21 l2_psum_7 73684.210526315786
R_L2_p_22_7 hidden_22 l2_psum_7 1000000
R_L2_p_23_7 hidden_23 l2_psum_7 34146.341463414632
R_L2_p_24_7 hidden_24 l2_psum_7 1000000
R_L2_p_25_7 hidden_25 l2_psum_7 73684.210526315786
R_L2_p_26_7 hidden_26 l2_psum_7 1000000
R_L2_p_27_7 hidden_27 l2_psum_7 95890.410958904104
R_L2_p_28_7 hidden_28 l2_psum_7 1000000
R_L2_p_29_7 hidden_29 l2_psum_7 1000000
R_L2_p_30_7 hidden_30 l2_psum_7 23026.315789473687
R_L2_p_31_7 hidden_31 l2_psum_7 1000000
R_L2_p_32_7 hidden_32 l2_psum_7 1000000
R_L2_p_33_7 hidden_33 l2_psum_7 54687.499999999993
R_L2_p_34_7 hidden_34 l2_psum_7 1000000
R_L2_p_35_7 hidden_35 l2_psum_7 388888.88888888888
R_L2_p_36_7 hidden_36 l2_psum_7 30837.004405286345
R_L2_p_37_7 hidden_37 l2_psum_7 46666.666666666664
R_L2_p_38_7 hidden_38 l2_psum_7 26923.076923076922
R_L2_p_39_7 hidden_39 l2_psum_7 43478.260869565216
R_L2_p_40_7 hidden_40 l2_psum_7 1000000
R_L2_p_41_7 hidden_41 l2_psum_7 95890.410958904104
R_L2_p_42_7 hidden_42 l2_psum_7 1000000
R_L2_p_43_7 hidden_43 l2_psum_7 1000000
R_L2_p_44_7 hidden_44 l2_psum_7 1000000
R_L2_p_45_7 hidden_45 l2_psum_7 73684.210526315786
R_L2_p_46_7 hidden_46 l2_psum_7 1000000
R_L2_p_47_7 hidden_47 l2_psum_7 112903.22580645159
R_L2_p_48_7 hidden_48 l2_psum_7 46666.666666666664
R_L2_p_49_7 hidden_49 l2_psum_7 32407.407407407409
E_TIA_L2_p_7 l2_pout_7 0 0 l2_psum_7 100000000
R_FB_L2_p_7 l2_pout_7 l2_psum_7 1000
R_L2_m_0_7 hidden_0 l2_msum_7 112903.22580645159
R_L2_m_1_7 hidden_1 l2_msum_7 1000000
R_L2_m_2_7 hidden_2 l2_msum_7 1000000
R_L2_m_3_7 hidden_3 l2_msum_7 40697.674418604649
R_L2_m_4_7 hidden_4 l2_msum_7 1000000
R_L2_m_5_7 hidden_5 l2_msum_7 1000000
R_L2_m_6_7 hidden_6 l2_msum_7 1000000
R_L2_m_7_7 hidden_7 l2_msum_7 29411.764705882353
R_L2_m_8_7 hidden_8 l2_msum_7 95890.410958904104
R_L2_m_9_7 hidden_9 l2_msum_7 1000000
R_L2_m_10_7 hidden_10 l2_msum_7 1000000
R_L2_m_11_7 hidden_11 l2_msum_7 1000000
R_L2_m_12_7 hidden_12 l2_msum_7 20771.51335311573
R_L2_m_13_7 hidden_13 l2_msum_7 1000000
R_L2_m_14_7 hidden_14 l2_msum_7 29411.764705882353
R_L2_m_15_7 hidden_15 l2_msum_7 241379.31034482759
R_L2_m_16_7 hidden_16 l2_msum_7 241379.31034482759
R_L2_m_17_7 hidden_17 l2_msum_7 36082.474226804123
R_L2_m_18_7 hidden_18 l2_msum_7 175000.00000000003
R_L2_m_19_7 hidden_19 l2_msum_7 1000000
R_L2_m_20_7 hidden_20 l2_msum_7 1000000
R_L2_m_21_7 hidden_21 l2_msum_7 1000000
R_L2_m_22_7 hidden_22 l2_msum_7 54687.499999999993
R_L2_m_23_7 hidden_23 l2_msum_7 1000000
R_L2_m_24_7 hidden_24 l2_msum_7 66037.735849056597
R_L2_m_25_7 hidden_25 l2_msum_7 1000000
R_L2_m_26_7 hidden_26 l2_msum_7 95890.410958904104
R_L2_m_27_7 hidden_27 l2_msum_7 1000000
R_L2_m_28_7 hidden_28 l2_msum_7 137254.90196078431
R_L2_m_29_7 hidden_29 l2_msum_7 73684.210526315786
R_L2_m_30_7 hidden_30 l2_msum_7 1000000
R_L2_m_31_7 hidden_31 l2_msum_7 34146.341463414632
R_L2_m_32_7 hidden_32 l2_msum_7 34146.341463414632
R_L2_m_33_7 hidden_33 l2_msum_7 1000000
R_L2_m_34_7 hidden_34 l2_msum_7 43478.260869565216
R_L2_m_35_7 hidden_35 l2_msum_7 1000000
R_L2_m_36_7 hidden_36 l2_msum_7 1000000
R_L2_m_37_7 hidden_37 l2_msum_7 1000000
R_L2_m_38_7 hidden_38 l2_msum_7 1000000
R_L2_m_39_7 hidden_39 l2_msum_7 1000000
R_L2_m_40_7 hidden_40 l2_msum_7 59829.059829059821
R_L2_m_41_7 hidden_41 l2_msum_7 1000000
R_L2_m_42_7 hidden_42 l2_msum_7 46666.666666666664
R_L2_m_43_7 hidden_43 l2_msum_7 1000000
R_L2_m_44_7 hidden_44 l2_msum_7 16908.212560386473
R_L2_m_45_7 hidden_45 l2_msum_7 1000000
R_L2_m_46_7 hidden_46 l2_msum_7 175000.00000000003
R_L2_m_47_7 hidden_47 l2_msum_7 1000000
R_L2_m_48_7 hidden_48 l2_msum_7 1000000
R_L2_m_49_7 hidden_49 l2_msum_7 1000000
E_TIA_L2_m_7 l2_mout_7 0 0 l2_msum_7 100000000
R_FB_L2_m_7 l2_mout_7 l2_msum_7 1000
B_NEURON_L2_7 logit_7 0 V={0.01*((V(l2_mout_7)-V(l2_pout_7))/0.00031049501254658707+(-0.027749828994274139))}
R_L2_p_0_8 hidden_0 l2_psum_8 38251.366120218576
R_L2_p_1_8 hidden_1 l2_psum_8 1000000
R_L2_p_2_8 hidden_2 l2_psum_8 38251.366120218576
R_L2_p_3_8 hidden_3 l2_psum_8 54687.499999999993
R_L2_p_4_8 hidden_4 l2_psum_8 1000000
R_L2_p_5_8 hidden_5 l2_psum_8 1000000
R_L2_p_6_8 hidden_6 l2_psum_8 1000000
R_L2_p_7_8 hidden_7 l2_psum_8 95890.410958904104
R_L2_p_8_8 hidden_8 l2_psum_8 46666.666666666664
R_L2_p_9_8 hidden_9 l2_psum_8 66037.735849056597
R_L2_p_10_8 hidden_10 l2_psum_8 1000000
R_L2_p_11_8 hidden_11 l2_psum_8 1000000
R_L2_p_12_8 hidden_12 l2_psum_8 1000000
R_L2_p_13_8 hidden_13 l2_psum_8 1000000
R_L2_p_14_8 hidden_14 l2_psum_8 1000000
R_L2_p_15_8 hidden_15 l2_psum_8 66037.735849056597
R_L2_p_16_8 hidden_16 l2_psum_8 66037.735849056597
R_L2_p_17_8 hidden_17 l2_psum_8 1000000
R_L2_p_18_8 hidden_18 l2_psum_8 50359.712230215831
R_L2_p_19_8 hidden_19 l2_psum_8 1000000
R_L2_p_20_8 hidden_20 l2_psum_8 1000000
R_L2_p_21_8 hidden_21 l2_psum_8 1000000
R_L2_p_22_8 hidden_22 l2_psum_8 46666.666666666664
R_L2_p_23_8 hidden_23 l2_psum_8 1000000
R_L2_p_24_8 hidden_24 l2_psum_8 95890.410958904104
R_L2_p_25_8 hidden_25 l2_psum_8 73684.210526315786
R_L2_p_26_8 hidden_26 l2_psum_8 1000000
R_L2_p_27_8 hidden_27 l2_psum_8 95890.410958904104
R_L2_p_28_8 hidden_28 l2_psum_8 1000000
R_L2_p_29_8 hidden_29 l2_psum_8 46666.666666666664
R_L2_p_30_8 hidden_30 l2_psum_8 1000000
R_L2_p_31_8 hidden_31 l2_psum_8 50359.712230215831
R_L2_p_32_8 hidden_32 l2_psum_8 1000000
R_L2_p_33_8 hidden_33 l2_psum_8 66037.735849056597
R_L2_p_34_8 hidden_34 l2_psum_8 95890.410958904104
R_L2_p_35_8 hidden_35 l2_psum_8 1000000
R_L2_p_36_8 hidden_36 l2_psum_8 1000000
R_L2_p_37_8 hidden_37 l2_psum_8 1000000
R_L2_p_38_8 hidden_38 l2_psum_8 1000000
R_L2_p_39_8 hidden_39 l2_psum_8 54687.499999999993
R_L2_p_40_8 hidden_40 l2_psum_8 1000000
R_L2_p_41_8 hidden_41 l2_psum_8 241379.31034482759
R_L2_p_42_8 hidden_42 l2_psum_8 46666.666666666664
R_L2_p_43_8 hidden_43 l2_psum_8 1000000
R_L2_p_44_8 hidden_44 l2_psum_8 1000000
R_L2_p_45_8 hidden_45 l2_psum_8 1000000
R_L2_p_46_8 hidden_46 l2_psum_8 1000000
R_L2_p_47_8 hidden_47 l2_psum_8 73684.210526315786
R_L2_p_48_8 hidden_48 l2_psum_8 1000000
R_L2_p_49_8 hidden_49 l2_psum_8 1000000
E_TIA_L2_p_8 l2_pout_8 0 0 l2_psum_8 100000000
R_FB_L2_p_8 l2_pout_8 l2_psum_8 1000
R_L2_m_0_8 hidden_0 l2_msum_8 1000000
R_L2_m_1_8 hidden_1 l2_msum_8 241379.31034482759
R_L2_m_2_8 hidden_2 l2_msum_8 1000000
R_L2_m_3_8 hidden_3 l2_msum_8 1000000
R_L2_m_4_8 hidden_4 l2_msum_8 46666.666666666664
R_L2_m_5_8 hidden_5 l2_msum_8 175000.00000000003
R_L2_m_6_8 hidden_6 l2_msum_8 34146.341463414632
R_L2_m_7_8 hidden_7 l2_msum_8 1000000
R_L2_m_8_8 hidden_8 l2_msum_8 1000000
R_L2_m_9_8 hidden_9 l2_msum_8 1000000
R_L2_m_10_8 hidden_10 l2_msum_8 36082.474226804123
R_L2_m_11_8 hidden_11 l2_msum_8 46666.666666666664
R_L2_m_12_8 hidden_12 l2_msum_8 175000.00000000003
R_L2_m_13_8 hidden_13 l2_msum_8 13358.778625954199
R_L2_m_14_8 hidden_14 l2_msum_8 112903.22580645159
R_L2_m_15_8 hidden_15 l2_msum_8 1000000
R_L2_m_16_8 hidden_16 l2_msum_8 1000000
R_L2_m_17_8 hidden_17 l2_msum_8 36082.474226804123
R_L2_m_18_8 hidden_18 l2_msum_8 1000000
R_L2_m_19_8 hidden_19 l2_msum_8 73684.210526315786
R_L2_m_20_8 hidden_20 l2_msum_8 38251.366120218576
R_L2_m_21_8 hidden_21 l2_msum_8 54687.499999999993
R_L2_m_22_8 hidden_22 l2_msum_8 1000000
R_L2_m_23_8 hidden_23 l2_msum_8 1000000
R_L2_m_24_8 hidden_24 l2_msum_8 1000000
R_L2_m_25_8 hidden_25 l2_msum_8 1000000
R_L2_m_26_8 hidden_26 l2_msum_8 137254.90196078431
R_L2_m_27_8 hidden_27 l2_msum_8 1000000
R_L2_m_28_8 hidden_28 l2_msum_8 36082.474226804123
R_L2_m_29_8 hidden_29 l2_msum_8 1000000
R_L2_m_30_8 hidden_30 l2_msum_8 38251.366120218576
R_L2_m_31_8 hidden_31 l2_msum_8 1000000
R_L2_m_32_8 hidden_32 l2_msum_8 241379.31034482759
R_L2_m_33_8 hidden_33 l2_msum_8 1000000
R_L2_m_34_8 hidden_34 l2_msum_8 1000000
R_L2_m_35_8 hidden_35 l2_msum_8 59829.059829059821
R_L2_m_36_8 hidden_36 l2_msum_8 59829.059829059821
R_L2_m_37_8 hidden_37 l2_msum_8 18918.91891891892
R_L2_m_38_8 hidden_38 l2_msum_8 32407.407407407409
R_L2_m_39_8 hidden_39 l2_msum_8 1000000
R_L2_m_40_8 hidden_40 l2_msum_8 10000
R_L2_m_41_8 hidden_41 l2_msum_8 1000000
R_L2_m_42_8 hidden_42 l2_msum_8 1000000
R_L2_m_43_8 hidden_43 l2_msum_8 34146.341463414632
R_L2_m_44_8 hidden_44 l2_msum_8 22222.222222222223
R_L2_m_45_8 hidden_45 l2_msum_8 40697.674418604649
R_L2_m_46_8 hidden_46 l2_msum_8 32407.407407407409
R_L2_m_47_8 hidden_47 l2_msum_8 1000000
R_L2_m_48_8 hidden_48 l2_msum_8 20114.942528735632
R_L2_m_49_8 hidden_49 l2_msum_8 175000.00000000003
E_TIA_L2_m_8 l2_mout_8 0 0 l2_msum_8 100000000
R_FB_L2_m_8 l2_mout_8 l2_msum_8 1000
B_NEURON_L2_8 logit_8 0 V={0.01*((V(l2_mout_8)-V(l2_pout_8))/0.00031049501254658707+(0.048424262553453445))}
R_L2_p_0_9 hidden_0 l2_psum_9 36082.474226804123
R_L2_p_1_9 hidden_1 l2_psum_9 83333.333333333328
R_L2_p_2_9 hidden_2 l2_psum_9 1000000
R_L2_p_3_9 hidden_3 l2_psum_9 1000000
R_L2_p_4_9 hidden_4 l2_psum_9 73684.210526315786
R_L2_p_5_9 hidden_5 l2_psum_9 38251.366120218576
R_L2_p_6_9 hidden_6 l2_psum_9 83333.333333333328
R_L2_p_7_9 hidden_7 l2_psum_9 1000000
R_L2_p_8_9 hidden_8 l2_psum_9 1000000
R_L2_p_9_9 hidden_9 l2_psum_9 1000000
R_L2_p_10_9 hidden_10 l2_psum_9 66037.735849056597
R_L2_p_11_9 hidden_11 l2_psum_9 1000000
R_L2_p_12_9 hidden_12 l2_psum_9 1000000
R_L2_p_13_9 hidden_13 l2_psum_9 46666.666666666664
R_L2_p_14_9 hidden_14 l2_psum_9 29411.764705882353
R_L2_p_15_9 hidden_15 l2_psum_9 1000000
R_L2_p_16_9 hidden_16 l2_psum_9 112903.22580645159
R_L2_p_17_9 hidden_17 l2_psum_9 1000000
R_L2_p_18_9 hidden_18 l2_psum_9 83333.333333333328
R_L2_p_19_9 hidden_19 l2_psum_9 1000000
R_L2_p_20_9 hidden_20 l2_psum_9 1000000
R_L2_p_21_9 hidden_21 l2_psum_9 1000000
R_L2_p_22_9 hidden_22 l2_psum_9 175000.00000000003
R_L2_p_23_9 hidden_23 l2_psum_9 50359.712230215831
R_L2_p_24_9 hidden_24 l2_psum_9 1000000
R_L2_p_25_9 hidden_25 l2_psum_9 54687.499999999993
R_L2_p_26_9 hidden_26 l2_psum_9 46666.666666666664
R_L2_p_27_9 hidden_27 l2_psum_9 83333.333333333328
R_L2_p_28_9 hidden_28 l2_psum_9 1000000
R_L2_p_29_9 hidden_29 l2_psum_9 66037.735849056597
R_L2_p_30_9 hidden_30 l2_psum_9 1000000
R_L2_p_31_9 hidden_31 l2_psum_9 73684.210526315786
R_L2_p_32_9 hidden_32 l2_psum_9 95890.410958904104
R_L2_p_33_9 hidden_33 l2_psum_9 50359.712230215831
R_L2_p_34_9 hidden_34 l2_psum_9 112903.22580645159
R_L2_p_35_9 hidden_35 l2_psum_9 1000000
R_L2_p_36_9 hidden_36 l2_psum_9 1000000
R_L2_p_37_9 hidden_37 l2_psum_9 54687.499999999993
R_L2_p_38_9 hidden_38 l2_psum_9 1000000
R_L2_p_39_9 hidden_39 l2_psum_9 1000000
R_L2_p_40_9 hidden_40 l2_psum_9 25830.258302583028
R_L2_p_41_9 hidden_41 l2_psum_9 241379.31034482759
R_L2_p_42_9 hidden_42 l2_psum_9 388888.88888888888
R_L2_p_43_9 hidden_43 l2_psum_9 1000000
R_L2_p_44_9 hidden_44 l2_psum_9 1000000
R_L2_p_45_9 hidden_45 l2_psum_9 1000000
R_L2_p_46_9 hidden_46 l2_psum_9 83333.333333333328
R_L2_p_47_9 hidden_47 l2_psum_9 1000000
R_L2_p_48_9 hidden_48 l2_psum_9 1000000
R_L2_p_49_9 hidden_49 l2_psum_9 1000000
E_TIA_L2_p_9 l2_pout_9 0 0 l2_psum_9 100000000
R_FB_L2_p_9 l2_pout_9 l2_psum_9 1000
R_L2_m_0_9 hidden_0 l2_msum_9 1000000
R_L2_m_1_9 hidden_1 l2_msum_9 1000000
R_L2_m_2_9 hidden_2 l2_msum_9 23890.784982935158
R_L2_m_3_9 hidden_3 l2_msum_9 175000.00000000003
R_L2_m_4_9 hidden_4 l2_msum_9 1000000
R_L2_m_5_9 hidden_5 l2_msum_9 1000000
R_L2_m_6_9 hidden_6 l2_msum_9 1000000
R_L2_m_7_9 hidden_7 l2_msum_9 241379.31034482759
R_L2_m_8_9 hidden_8 l2_msum_9 34146.341463414632
R_L2_m_9_9 hidden_9 l2_msum_9 24822.695035460994
R_L2_m_10_9 hidden_10 l2_msum_9 1000000
R_L2_m_11_9 hidden_11 l2_msum_9 21472.39263803681
R_L2_m_12_9 hidden_12 l2_msum_9 54687.499999999993
R_L2_m_13_9 hidden_13 l2_msum_9 1000000
R_L2_m_14_9 hidden_14 l2_msum_9 1000000
R_L2_m_15_9 hidden_15 l2_msum_9 66037.735849056597
R_L2_m_16_9 hidden_16 l2_msum_9 1000000
R_L2_m_17_9 hidden_17 l2_msum_9 40697.674418604649
R_L2_m_18_9 hidden_18 l2_msum_9 1000000
R_L2_m_19_9 hidden_19 l2_msum_9 18918.91891891892
R_L2_m_20_9 hidden_20 l2_msum_9 28112.449799196787
R_L2_m_21_9 hidden_21 l2_msum_9 20114.942528735632
R_L2_m_22_9 hidden_22 l2_msum_9 1000000
R_L2_m_23_9 hidden_23 l2_msum_9 1000000
R_L2_m_24_9 hidden_24 l2_msum_9 241379.31034482759
R_L2_m_25_9 hidden_25 l2_msum_9 1000000
R_L2_m_26_9 hidden_26 l2_msum_9 1000000
R_L2_m_27_9 hidden_27 l2_msum_9 1000000
R_L2_m_28_9 hidden_28 l2_msum_9 95890.410958904104
R_L2_m_29_9 hidden_29 l2_msum_9 1000000
R_L2_m_30_9 hidden_30 l2_msum_9 388888.88888888888
R_L2_m_31_9 hidden_31 l2_msum_9 1000000
R_L2_m_32_9 hidden_32 l2_msum_9 1000000
R_L2_m_33_9 hidden_33 l2_msum_9 1000000
R_L2_m_34_9 hidden_34 l2_msum_9 1000000
R_L2_m_35_9 hidden_35 l2_msum_9 17857.142857142859
R_L2_m_36_9 hidden_36 l2_msum_9 50359.712230215831
R_L2_m_37_9 hidden_37 l2_msum_9 1000000
R_L2_m_38_9 hidden_38 l2_msum_9 66037.735849056597
R_L2_m_39_9 hidden_39 l2_msum_9 12567.324955116697
R_L2_m_40_9 hidden_40 l2_msum_9 1000000
R_L2_m_41_9 hidden_41 l2_msum_9 1000000
R_L2_m_42_9 hidden_42 l2_msum_9 1000000
R_L2_m_43_9 hidden_43 l2_msum_9 13645.22417153996
R_L2_m_44_9 hidden_44 l2_msum_9 20114.942528735632
R_L2_m_45_9 hidden_45 l2_msum_9 388888.88888888888
R_L2_m_46_9 hidden_46 l2_msum_9 1000000
R_L2_m_47_9 hidden_47 l2_msum_9 83333.333333333328
R_L2_m_48_9 hidden_48 l2_msum_9 15283.842794759827
R_L2_m_49_9 hidden_49 l2_msum_9 17857.142857142859
E_TIA_L2_m_9 l2_mout_9 0 0 l2_msum_9 100000000
R_FB_L2_m_9 l2_mout_9 l2_msum_9 1000
B_NEURON_L2_9 logit_9 0 V={0.01*((V(l2_mout_9)-V(l2_pout_9))/0.00031049501254658707+(0.059930931776762009))}
.save v(logit_0) v(logit_1) v(logit_2) v(logit_3) v(logit_4) v(logit_5) v(logit_6) v(logit_7) v(logit_8) v(logit_9)
.tran 10n 10u 0 10n
.measure tran logit_0_V find v(logit_0) at=8u
.measure tran logit_1_V find v(logit_1) at=8u
.measure tran logit_2_V find v(logit_2) at=8u
.measure tran logit_3_V find v(logit_3) at=8u
.measure tran logit_4_V find v(logit_4) at=8u
.measure tran logit_5_V find v(logit_5) at=8u
.measure tran logit_6_V find v(logit_6) at=8u
.measure tran logit_7_V find v(logit_7) at=8u
.measure tran logit_8_V find v(logit_8) at=8u
.measure tran logit_9_V find v(logit_9) at=8u
.control
set wr_vecnames
set wr_singlescale
set numdgt=17
run
wrdata ngspice_sample_00015_logits.txt v(logit_0) v(logit_1) v(logit_2) v(logit_3) v(logit_4) v(logit_5) v(logit_6) v(logit_7) v(logit_8) v(logit_9)
.endc
.end
